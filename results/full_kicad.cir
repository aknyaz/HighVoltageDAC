.title KiCad schematic
.include "../kicad/full/hv_rdac_models.lib"
.tran 200n 100m 0 200n
.options reltol=1e-6 abstol=1e-12
V1 /VREF GND DC 5
R5 /A0 /A1 1k
R8 /A0 GND 2k
XU5 /CA0 GND PCM_A0
R1 /A0 Net-_U1-OUT_ 2k
XU1 /VREF GND Net-_U1-OUT_ /CA0 RDAC_SPDT
R2 /A1 Net-_U2-OUT_ 2k
XU2 /VREF GND Net-_U2-OUT_ /CA1 RDAC_SPDT
XU6 /CA1 GND PCM_A1
R6 /A1 /A2 1k
R14 /B1 /B2 1k
R10 /B1 Net-_U10-OUT_ 2k
XU10 /VREF GND Net-_U10-OUT_ /CB1 RDAC_SPDT
R3 /A2 Net-_U3-OUT_ 2k
XU3 /VREF GND Net-_U3-OUT_ /CA2 RDAC_SPDT
R7 /A2 /A3 1k
R4 /A3 Net-_U4-OUT_ 2k
XU4 /VREF GND Net-_U4-OUT_ /CA3 RDAC_SPDT
XU8 /CA3 GND PCM_A3
XU7 /CA2 GND PCM_A2
XT1 /A3 /B3 /SEC GND RDAC_TRANSFORMER
R17 /SEC GND 8
R11 /B2 Net-_U11-OUT_ 2k
R15 /B2 /B3 1k
XU16 /CB3 GND PCM_B3
R12 /B3 Net-_U12-OUT_ 2k
XU12 /VREF GND Net-_U12-OUT_ /CB3 RDAC_SPDT
XU15 /CB2 GND PCM_B2
XU11 /VREF GND Net-_U11-OUT_ /CB2 RDAC_SPDT
R9 /B0 Net-_U9-OUT_ 2k
R13 /B0 /B1 1k
XU13 /CB0 GND PCM_B0
XU9 /VREF GND Net-_U9-OUT_ /CB0 RDAC_SPDT
XU14 /CB1 GND PCM_B1
R16 /B0 GND 2k
.end
