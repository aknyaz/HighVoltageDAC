.title KiCad schematic
.include "../kicad/parallel/hv_rdac_models.lib"
.tran 200n 100m 0 200n
.options reltol=1e-6 abstol=1e-12
R8 /AOUT GND 16k
R1 /AOUT Net-_U1-OUT_ 16k
V1 /VREF GND DC 5
XU1 /VREF GND Net-_U1-OUT_ /CA0 RDAC_SPDT
XU5 /CA0 GND PCM_A0
XT1 /AOUT /BOUT /SEC GND RDAC_TRANSFORMER
R17 /SEC GND 8
XU6 /CA1 GND PCM_A1
R3 /AOUT Net-_U3-OUT_ 4k
R2 /AOUT Net-_U2-OUT_ 8k
XU2 /VREF GND Net-_U2-OUT_ /CA1 RDAC_SPDT
XU7 /CA2 GND PCM_A2
XU3 /VREF GND Net-_U3-OUT_ /CA2 RDAC_SPDT
R4 /AOUT Net-_U4-OUT_ 2k
XU4 /VREF GND Net-_U4-OUT_ /CA3 RDAC_SPDT
XU8 /CA3 GND PCM_A3
R16 /BOUT GND 16k
R11 /BOUT Net-_U11-OUT_ 4k
XU15 /CB2 GND PCM_B2
XU12 /VREF GND Net-_U12-OUT_ /CB3 RDAC_SPDT
R12 /BOUT Net-_U12-OUT_ 2k
XU16 /CB3 GND PCM_B3
XU11 /VREF GND Net-_U11-OUT_ /CB2 RDAC_SPDT
XU13 /CB0 GND PCM_B0
R9 /BOUT Net-_U9-OUT_ 16k
R10 /BOUT Net-_U10-OUT_ 8k
XU9 /VREF GND Net-_U9-OUT_ /CB0 RDAC_SPDT
XU10 /VREF GND Net-_U10-OUT_ /CB1 RDAC_SPDT
XU14 /CB1 GND PCM_B1
.end
