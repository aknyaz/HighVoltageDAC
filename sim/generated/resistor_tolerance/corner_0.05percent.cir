12-bit parallel mismatch verification - 5 V only
Vref ref 0 5
Vcode code 0 0
.model ideal SW(Ron=1u Roff=1e12 Vt=.5 Vh=0)
.options reltol=1e-8 abstol=1e-14
Bca0 ca0 0 V=floor(v(code)/1)-2*floor(v(code)/2)
Bna0 na0 0 V=1-v(ca0)
Sa0h da0 ref ca0 0 ideal
Sa0l da0 0 na0 0 ideal
Ra0 a da0 21594367.0902292
Bca1 ca1 0 V=floor(v(code)/2)-2*floor(v(code)/4)
Bna1 na1 0 V=1-v(ca1)
Sa1h da1 ref ca1 0 ideal
Sa1l da1 0 na1 0 ideal
Ra1 a da1 10797183.5451146
Bca2 ca2 0 V=floor(v(code)/4)-2*floor(v(code)/8)
Bna2 na2 0 V=1-v(ca2)
Sa2h da2 ref ca2 0 ideal
Sa2l da2 0 na2 0 ideal
Ra2 a da2 5398591.77255729
Bca3 ca3 0 V=floor(v(code)/8)-2*floor(v(code)/16)
Bna3 na3 0 V=1-v(ca3)
Sa3h da3 ref ca3 0 ideal
Sa3l da3 0 na3 0 ideal
Ra3 a da3 2699295.88627865
Bca4 ca4 0 V=floor(v(code)/16)-2*floor(v(code)/32)
Bna4 na4 0 V=1-v(ca4)
Sa4h da4 ref ca4 0 ideal
Sa4l da4 0 na4 0 ideal
Ra4 a da4 1349647.94313932
Bca5 ca5 0 V=floor(v(code)/32)-2*floor(v(code)/64)
Bna5 na5 0 V=1-v(ca5)
Sa5h da5 ref ca5 0 ideal
Sa5l da5 0 na5 0 ideal
Ra5 a da5 674823.971569662
Bca6 ca6 0 V=floor(v(code)/64)-2*floor(v(code)/128)
Bna6 na6 0 V=1-v(ca6)
Sa6h da6 ref ca6 0 ideal
Sa6l da6 0 na6 0 ideal
Ra6 a da6 337411.985784831
Bca7 ca7 0 V=floor(v(code)/128)-2*floor(v(code)/256)
Bna7 na7 0 V=1-v(ca7)
Sa7h da7 ref ca7 0 ideal
Sa7l da7 0 na7 0 ideal
Ra7 a da7 168705.992892415
Bca8 ca8 0 V=floor(v(code)/256)-2*floor(v(code)/512)
Bna8 na8 0 V=1-v(ca8)
Sa8h da8 ref ca8 0 ideal
Sa8l da8 0 na8 0 ideal
Ra8 a da8 84352.9964462077
Bca9 ca9 0 V=floor(v(code)/512)-2*floor(v(code)/1024)
Bna9 na9 0 V=1-v(ca9)
Sa9h da9 ref ca9 0 ideal
Sa9l da9 0 na9 0 ideal
Ra9 a da9 42176.4982231039
Bca10 ca10 0 V=floor(v(code)/1024)-2*floor(v(code)/2048)
Bna10 na10 0 V=1-v(ca10)
Sa10h da10 ref ca10 0 ideal
Sa10l da10 0 na10 0 ideal
Ra10 a da10 21088.2491115519
Bca11 ca11 0 V=floor(v(code)/2048)-2*floor(v(code)/4096)
Bna11 na11 0 V=1-v(ca11)
Sa11h da11 ref ca11 0 ideal
Sa11l da11 0 na11 0 ideal
Ra11 a da11 10554.6739550314
Raterm a 0 21605169.6750667
Bcb0 cb0 0 V=1-(floor(v(code)/1)-2*floor(v(code)/2))
Bnb0 nb0 0 V=1-v(cb0)
Sb0h db0 ref cb0 0 ideal
Sb0l db0 0 nb0 0 ideal
Rb0 b db0 21594367.0902292
Bcb1 cb1 0 V=1-(floor(v(code)/2)-2*floor(v(code)/4))
Bnb1 nb1 0 V=1-v(cb1)
Sb1h db1 ref cb1 0 ideal
Sb1l db1 0 nb1 0 ideal
Rb1 b db1 10797183.5451146
Bcb2 cb2 0 V=1-(floor(v(code)/4)-2*floor(v(code)/8))
Bnb2 nb2 0 V=1-v(cb2)
Sb2h db2 ref cb2 0 ideal
Sb2l db2 0 nb2 0 ideal
Rb2 b db2 5398591.77255729
Bcb3 cb3 0 V=1-(floor(v(code)/8)-2*floor(v(code)/16))
Bnb3 nb3 0 V=1-v(cb3)
Sb3h db3 ref cb3 0 ideal
Sb3l db3 0 nb3 0 ideal
Rb3 b db3 2699295.88627865
Bcb4 cb4 0 V=1-(floor(v(code)/16)-2*floor(v(code)/32))
Bnb4 nb4 0 V=1-v(cb4)
Sb4h db4 ref cb4 0 ideal
Sb4l db4 0 nb4 0 ideal
Rb4 b db4 1349647.94313932
Bcb5 cb5 0 V=1-(floor(v(code)/32)-2*floor(v(code)/64))
Bnb5 nb5 0 V=1-v(cb5)
Sb5h db5 ref cb5 0 ideal
Sb5l db5 0 nb5 0 ideal
Rb5 b db5 674823.971569662
Bcb6 cb6 0 V=1-(floor(v(code)/64)-2*floor(v(code)/128))
Bnb6 nb6 0 V=1-v(cb6)
Sb6h db6 ref cb6 0 ideal
Sb6l db6 0 nb6 0 ideal
Rb6 b db6 337411.985784831
Bcb7 cb7 0 V=1-(floor(v(code)/128)-2*floor(v(code)/256))
Bnb7 nb7 0 V=1-v(cb7)
Sb7h db7 ref cb7 0 ideal
Sb7l db7 0 nb7 0 ideal
Rb7 b db7 168705.992892415
Bcb8 cb8 0 V=1-(floor(v(code)/256)-2*floor(v(code)/512))
Bnb8 nb8 0 V=1-v(cb8)
Sb8h db8 ref cb8 0 ideal
Sb8l db8 0 nb8 0 ideal
Rb8 b db8 84352.9964462077
Bcb9 cb9 0 V=1-(floor(v(code)/512)-2*floor(v(code)/1024))
Bnb9 nb9 0 V=1-v(cb9)
Sb9h db9 ref cb9 0 ideal
Sb9l db9 0 nb9 0 ideal
Rb9 b db9 42176.4982231039
Bcb10 cb10 0 V=1-(floor(v(code)/1024)-2*floor(v(code)/2048))
Bnb10 nb10 0 V=1-v(cb10)
Sb10h db10 ref cb10 0 ideal
Sb10l db10 0 nb10 0 ideal
Rb10 b db10 21088.2491115519
Bcb11 cb11 0 V=1-(floor(v(code)/2048)-2*floor(v(code)/4096))
Bnb11 nb11 0 V=1-v(cb11)
Sb11h db11 ref cb11 0 ideal
Sb11l db11 0 nb11 0 ideal
Rb11 b db11 10554.6739550314
Rbterm b 0 21605169.6750667
Rload a b 10000
.dc Vcode 0 4095 1
.end
