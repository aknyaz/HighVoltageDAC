Partition mismatch full-code verification, 5 V
Vref ref 0 5
Vcode code 0 0
.model sw SW(Ron=1u Roff=1e12 Vt=.5 Vh=0)
.options reltol=1e-8 abstol=1e-14
Bca0 ca0 0 V=floor(v(code)/1)-2*floor(v(code)/2)
Bna0 na0 0 V=1-v(ca0)
Sha0 da0 ref ca0 0 sw
Sla0 da0 0 na0 0 sw
Ra0 a da0 21605169.6750667
Bca1 ca1 0 V=floor(v(code)/2)-2*floor(v(code)/4)
Bna1 na1 0 V=1-v(ca1)
Sha1 da1 ref ca1 0 sw
Sla1 da1 0 na1 0 sw
Ra1 a da1 10802584.8375334
Bca2 ca2 0 V=floor(v(code)/4)-2*floor(v(code)/8)
Bna2 na2 0 V=1-v(ca2)
Sha2 da2 ref ca2 0 sw
Sla2 da2 0 na2 0 sw
Ra2 a da2 5401292.41876668
Bca3 ca3 0 V=floor(v(code)/8)-2*floor(v(code)/16)
Bna3 na3 0 V=1-v(ca3)
Sha3 da3 ref ca3 0 sw
Sla3 da3 0 na3 0 sw
Ra3 a da3 2700646.20938334
Bca4 ca4 0 V=floor(v(code)/16)-2*floor(v(code)/32)
Bna4 na4 0 V=1-v(ca4)
Sha4 da4 ref ca4 0 sw
Sla4 da4 0 na4 0 sw
Ra4 a da4 1350323.10469167
Bca5 ca5 0 V=floor(v(code)/32)-2*floor(v(code)/64)
Bna5 na5 0 V=1-v(ca5)
Sha5 da5 ref ca5 0 sw
Sla5 da5 0 na5 0 sw
Ra5 a da5 675161.552345835
Bca6 ca6 0 V=floor(v(code)/64)-2*floor(v(code)/128)
Bna6 na6 0 V=1-v(ca6)
Sha6 da6 ref ca6 0 sw
Sla6 da6 0 na6 0 sw
Ra6 a da6 337580.776172917
Bca7 ca7 0 V=floor(v(code)/128)-2*floor(v(code)/256)
Bna7 na7 0 V=1-v(ca7)
Sha7 da7 ref ca7 0 sw
Sla7 da7 0 na7 0 sw
Ra7 a da7 168790.388086459
Bca8 ca8 0 V=floor(v(code)/256)-2*floor(v(code)/512)
Bna8 na8 0 V=1-v(ca8)
Sha8 da8 ref ca8 0 sw
Sla8 da8 0 na8 0 sw
Ra8 a da8 84395.1940432293
Bca9 ca9 0 V=(floor(v(code)/512)>0)
Bna9 na9 0 V=1-v(ca9)
Sha9 da9 ref ca9 0 sw
Sla9 da9 0 na9 0 sw
Ra9 a da9 42197.5970216147
Bca10 ca10 0 V=(floor(v(code)/512)>1)
Bna10 na10 0 V=1-v(ca10)
Sha10 da10 ref ca10 0 sw
Sla10 da10 0 na10 0 sw
Ra10 a da10 42197.5970216147
Bca11 ca11 0 V=(floor(v(code)/512)>2)
Bna11 na11 0 V=1-v(ca11)
Sha11 da11 ref ca11 0 sw
Sla11 da11 0 na11 0 sw
Ra11 a da11 42197.5970216147
Bca12 ca12 0 V=(floor(v(code)/512)>3)
Bna12 na12 0 V=1-v(ca12)
Sha12 da12 ref ca12 0 sw
Sla12 da12 0 na12 0 sw
Ra12 a da12 42197.5970216147
Bca13 ca13 0 V=(floor(v(code)/512)>4)
Bna13 na13 0 V=1-v(ca13)
Sha13 da13 ref ca13 0 sw
Sla13 da13 0 na13 0 sw
Ra13 a da13 42197.5970216147
Bca14 ca14 0 V=(floor(v(code)/512)>5)
Bna14 na14 0 V=1-v(ca14)
Sha14 da14 ref ca14 0 sw
Sla14 da14 0 na14 0 sw
Ra14 a da14 42197.5970216147
Bca15 ca15 0 V=(floor(v(code)/512)>6)
Bna15 na15 0 V=1-v(ca15)
Sha15 da15 ref ca15 0 sw
Sla15 da15 0 na15 0 sw
Ra15 a da15 42197.5970216147
Raterm a 0 21605169.6750667
Bcb0 cb0 0 V=floor((4095-v(code))/1)-2*floor((4095-v(code))/2)
Bnb0 nb0 0 V=1-v(cb0)
Shb0 db0 ref cb0 0 sw
Slb0 db0 0 nb0 0 sw
Rb0 b db0 21605169.6750667
Bcb1 cb1 0 V=floor((4095-v(code))/2)-2*floor((4095-v(code))/4)
Bnb1 nb1 0 V=1-v(cb1)
Shb1 db1 ref cb1 0 sw
Slb1 db1 0 nb1 0 sw
Rb1 b db1 10802584.8375334
Bcb2 cb2 0 V=floor((4095-v(code))/4)-2*floor((4095-v(code))/8)
Bnb2 nb2 0 V=1-v(cb2)
Shb2 db2 ref cb2 0 sw
Slb2 db2 0 nb2 0 sw
Rb2 b db2 5401292.41876668
Bcb3 cb3 0 V=floor((4095-v(code))/8)-2*floor((4095-v(code))/16)
Bnb3 nb3 0 V=1-v(cb3)
Shb3 db3 ref cb3 0 sw
Slb3 db3 0 nb3 0 sw
Rb3 b db3 2700646.20938334
Bcb4 cb4 0 V=floor((4095-v(code))/16)-2*floor((4095-v(code))/32)
Bnb4 nb4 0 V=1-v(cb4)
Shb4 db4 ref cb4 0 sw
Slb4 db4 0 nb4 0 sw
Rb4 b db4 1350323.10469167
Bcb5 cb5 0 V=floor((4095-v(code))/32)-2*floor((4095-v(code))/64)
Bnb5 nb5 0 V=1-v(cb5)
Shb5 db5 ref cb5 0 sw
Slb5 db5 0 nb5 0 sw
Rb5 b db5 675161.552345835
Bcb6 cb6 0 V=floor((4095-v(code))/64)-2*floor((4095-v(code))/128)
Bnb6 nb6 0 V=1-v(cb6)
Shb6 db6 ref cb6 0 sw
Slb6 db6 0 nb6 0 sw
Rb6 b db6 337580.776172917
Bcb7 cb7 0 V=floor((4095-v(code))/128)-2*floor((4095-v(code))/256)
Bnb7 nb7 0 V=1-v(cb7)
Shb7 db7 ref cb7 0 sw
Slb7 db7 0 nb7 0 sw
Rb7 b db7 168790.388086459
Bcb8 cb8 0 V=floor((4095-v(code))/256)-2*floor((4095-v(code))/512)
Bnb8 nb8 0 V=1-v(cb8)
Shb8 db8 ref cb8 0 sw
Slb8 db8 0 nb8 0 sw
Rb8 b db8 84395.1940432293
Bcb9 cb9 0 V=(floor((4095-v(code))/512)>0)
Bnb9 nb9 0 V=1-v(cb9)
Shb9 db9 ref cb9 0 sw
Slb9 db9 0 nb9 0 sw
Rb9 b db9 42197.5970216147
Bcb10 cb10 0 V=(floor((4095-v(code))/512)>1)
Bnb10 nb10 0 V=1-v(cb10)
Shb10 db10 ref cb10 0 sw
Slb10 db10 0 nb10 0 sw
Rb10 b db10 42197.5970216147
Bcb11 cb11 0 V=(floor((4095-v(code))/512)>2)
Bnb11 nb11 0 V=1-v(cb11)
Shb11 db11 ref cb11 0 sw
Slb11 db11 0 nb11 0 sw
Rb11 b db11 42197.5970216147
Bcb12 cb12 0 V=(floor((4095-v(code))/512)>3)
Bnb12 nb12 0 V=1-v(cb12)
Shb12 db12 ref cb12 0 sw
Slb12 db12 0 nb12 0 sw
Rb12 b db12 42197.5970216147
Bcb13 cb13 0 V=(floor((4095-v(code))/512)>4)
Bnb13 nb13 0 V=1-v(cb13)
Shb13 db13 ref cb13 0 sw
Slb13 db13 0 nb13 0 sw
Rb13 b db13 42197.5970216147
Bcb14 cb14 0 V=(floor((4095-v(code))/512)>5)
Bnb14 nb14 0 V=1-v(cb14)
Shb14 db14 ref cb14 0 sw
Slb14 db14 0 nb14 0 sw
Rb14 b db14 42197.5970216147
Bcb15 cb15 0 V=(floor((4095-v(code))/512)>6)
Bnb15 nb15 0 V=1-v(cb15)
Shb15 db15 ref cb15 0 sw
Slb15 db15 0 nb15 0 sw
Rb15 b db15 42197.5970216147
Rbterm b 0 21605169.6750667
Rload a b 10000.0
.dc Vcode 0 4095 1
.end
