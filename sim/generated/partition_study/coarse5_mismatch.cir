Partition mismatch full-code verification, 5 V
Vref ref 0 5
Vcode code 0 0
.model sw SW(Ron=1u Roff=1e12 Vt=.5 Vh=0)
.options reltol=1e-8 abstol=1e-14
Bca0 ca0 0 V=floor(v(code)/1)-2*floor(v(code)/2)
Bna0 na0 0 V=1-v(ca0)
Sha0 da0 ref ca0 0 sw
Sla0 da0 0 na0 0 sw
Ra0 a da0 21606577.8200194
Bca1 ca1 0 V=floor(v(code)/2)-2*floor(v(code)/4)
Bna1 na1 0 V=1-v(ca1)
Sha1 da1 ref ca1 0 sw
Sla1 da1 0 na1 0 sw
Ra1 a da1 10803492.5136842
Bca2 ca2 0 V=floor(v(code)/4)-2*floor(v(code)/8)
Bna2 na2 0 V=1-v(ca2)
Sha2 da2 ref ca2 0 sw
Sla2 da2 0 na2 0 sw
Ra2 a da2 5400756.4585858
Bca3 ca3 0 V=floor(v(code)/8)-2*floor(v(code)/16)
Bna3 na3 0 V=1-v(ca3)
Sha3 da3 ref ca3 0 sw
Sla3 da3 0 na3 0 sw
Ra3 a da3 2700407.3130336
Bca4 ca4 0 V=floor(v(code)/16)-2*floor(v(code)/32)
Bna4 na4 0 V=1-v(ca4)
Sha4 da4 ref ca4 0 sw
Sla4 da4 0 na4 0 sw
Ra4 a da4 1350365.13868797
Bca5 ca5 0 V=floor(v(code)/32)-2*floor(v(code)/64)
Bna5 na5 0 V=1-v(ca5)
Sha5 da5 ref ca5 0 sw
Sla5 da5 0 na5 0 sw
Ra5 a da5 675095.723638155
Bca6 ca6 0 V=floor(v(code)/64)-2*floor(v(code)/128)
Bna6 na6 0 V=1-v(ca6)
Sha6 da6 ref ca6 0 sw
Sla6 da6 0 na6 0 sw
Ra6 a da6 337573.872534441
Bca7 ca7 0 V=(floor(v(code)/128)>0)
Bna7 na7 0 V=1-v(ca7)
Sha7 da7 ref ca7 0 sw
Sla7 da7 0 na7 0 sw
Ra7 a da7 168773.861824317
Bca8 ca8 0 V=(floor(v(code)/128)>1)
Bna8 na8 0 V=1-v(ca8)
Sha8 da8 ref ca8 0 sw
Sla8 da8 0 na8 0 sw
Ra8 a da8 168775.325359292
Bca9 ca9 0 V=(floor(v(code)/128)>2)
Bna9 na9 0 V=1-v(ca9)
Sha9 da9 ref ca9 0 sw
Sla9 da9 0 na9 0 sw
Ra9 a da9 168794.324587816
Bca10 ca10 0 V=(floor(v(code)/128)>3)
Bna10 na10 0 V=1-v(ca10)
Sha10 da10 ref ca10 0 sw
Sla10 da10 0 na10 0 sw
Ra10 a da10 168776.842995892
Bca11 ca11 0 V=(floor(v(code)/128)>4)
Bna11 na11 0 V=1-v(ca11)
Sha11 da11 ref ca11 0 sw
Sla11 da11 0 na11 0 sw
Ra11 a da11 168797.321605231
Bca12 ca12 0 V=(floor(v(code)/128)>5)
Bna12 na12 0 V=1-v(ca12)
Sha12 da12 ref ca12 0 sw
Sla12 da12 0 na12 0 sw
Ra12 a da12 168797.297506688
Bca13 ca13 0 V=(floor(v(code)/128)>6)
Bna13 na13 0 V=1-v(ca13)
Sha13 da13 ref ca13 0 sw
Sla13 da13 0 na13 0 sw
Ra13 a da13 168796.304658738
Bca14 ca14 0 V=(floor(v(code)/128)>7)
Bna14 na14 0 V=1-v(ca14)
Sha14 da14 ref ca14 0 sw
Sla14 da14 0 na14 0 sw
Ra14 a da14 168783.574692583
Bca15 ca15 0 V=(floor(v(code)/128)>8)
Bna15 na15 0 V=1-v(ca15)
Sha15 da15 ref ca15 0 sw
Sla15 da15 0 na15 0 sw
Ra15 a da15 168778.002715014
Bca16 ca16 0 V=(floor(v(code)/128)>9)
Bna16 na16 0 V=1-v(ca16)
Sha16 da16 ref ca16 0 sw
Sla16 da16 0 na16 0 sw
Ra16 a da16 168776.835437521
Bca17 ca17 0 V=(floor(v(code)/128)>10)
Bna17 na17 0 V=1-v(ca17)
Sha17 da17 ref ca17 0 sw
Sla17 da17 0 na17 0 sw
Ra17 a da17 168774.233366854
Bca18 ca18 0 V=(floor(v(code)/128)>11)
Bna18 na18 0 V=1-v(ca18)
Sha18 da18 ref ca18 0 sw
Sla18 da18 0 na18 0 sw
Ra18 a da18 168802.363715947
Bca19 ca19 0 V=(floor(v(code)/128)>12)
Bna19 na19 0 V=1-v(ca19)
Sha19 da19 ref ca19 0 sw
Sla19 da19 0 na19 0 sw
Ra19 a da19 168777.349628357
Bca20 ca20 0 V=(floor(v(code)/128)>13)
Bna20 na20 0 V=1-v(ca20)
Sha20 da20 ref ca20 0 sw
Sla20 da20 0 na20 0 sw
Ra20 a da20 168775.413029295
Bca21 ca21 0 V=(floor(v(code)/128)>14)
Bna21 na21 0 V=1-v(ca21)
Sha21 da21 ref ca21 0 sw
Sla21 da21 0 na21 0 sw
Ra21 a da21 168788.668825776
Bca22 ca22 0 V=(floor(v(code)/128)>15)
Bna22 na22 0 V=1-v(ca22)
Sha22 da22 ref ca22 0 sw
Sla22 da22 0 na22 0 sw
Ra22 a da22 168798.876802727
Bca23 ca23 0 V=(floor(v(code)/128)>16)
Bna23 na23 0 V=1-v(ca23)
Sha23 da23 ref ca23 0 sw
Sla23 da23 0 na23 0 sw
Ra23 a da23 168796.415512198
Bca24 ca24 0 V=(floor(v(code)/128)>17)
Bna24 na24 0 V=1-v(ca24)
Sha24 da24 ref ca24 0 sw
Sla24 da24 0 na24 0 sw
Ra24 a da24 168802.315778966
Bca25 ca25 0 V=(floor(v(code)/128)>18)
Bna25 na25 0 V=1-v(ca25)
Sha25 da25 ref ca25 0 sw
Sla25 da25 0 na25 0 sw
Ra25 a da25 168785.077922647
Bca26 ca26 0 V=(floor(v(code)/128)>19)
Bna26 na26 0 V=1-v(ca26)
Sha26 da26 ref ca26 0 sw
Sla26 da26 0 na26 0 sw
Ra26 a da26 168804.212301368
Bca27 ca27 0 V=(floor(v(code)/128)>20)
Bna27 na27 0 V=1-v(ca27)
Sha27 da27 ref ca27 0 sw
Sla27 da27 0 na27 0 sw
Ra27 a da27 168786.554875729
Bca28 ca28 0 V=(floor(v(code)/128)>21)
Bna28 na28 0 V=1-v(ca28)
Sha28 da28 ref ca28 0 sw
Sla28 da28 0 na28 0 sw
Ra28 a da28 168803.893388583
Bca29 ca29 0 V=(floor(v(code)/128)>22)
Bna29 na29 0 V=1-v(ca29)
Sha29 da29 ref ca29 0 sw
Sla29 da29 0 na29 0 sw
Ra29 a da29 168796.591588234
Bca30 ca30 0 V=(floor(v(code)/128)>23)
Bna30 na30 0 V=1-v(ca30)
Sha30 da30 ref ca30 0 sw
Sla30 da30 0 na30 0 sw
Ra30 a da30 168787.185448333
Bca31 ca31 0 V=(floor(v(code)/128)>24)
Bna31 na31 0 V=1-v(ca31)
Sha31 da31 ref ca31 0 sw
Sla31 da31 0 na31 0 sw
Ra31 a da31 168788.991987
Bca32 ca32 0 V=(floor(v(code)/128)>25)
Bna32 na32 0 V=1-v(ca32)
Sha32 da32 ref ca32 0 sw
Sla32 da32 0 na32 0 sw
Ra32 a da32 168800.323313037
Bca33 ca33 0 V=(floor(v(code)/128)>26)
Bna33 na33 0 V=1-v(ca33)
Sha33 da33 ref ca33 0 sw
Sla33 da33 0 na33 0 sw
Ra33 a da33 168806.035075807
Bca34 ca34 0 V=(floor(v(code)/128)>27)
Bna34 na34 0 V=1-v(ca34)
Sha34 da34 ref ca34 0 sw
Sla34 da34 0 na34 0 sw
Ra34 a da34 168800.25441526
Bca35 ca35 0 V=(floor(v(code)/128)>28)
Bna35 na35 0 V=1-v(ca35)
Sha35 da35 ref ca35 0 sw
Sla35 da35 0 na35 0 sw
Ra35 a da35 168803.854342069
Bca36 ca36 0 V=(floor(v(code)/128)>29)
Bna36 na36 0 V=1-v(ca36)
Sha36 da36 ref ca36 0 sw
Sla36 da36 0 na36 0 sw
Ra36 a da36 168806.966832065
Bca37 ca37 0 V=(floor(v(code)/128)>30)
Bna37 na37 0 V=1-v(ca37)
Sha37 da37 ref ca37 0 sw
Sla37 da37 0 na37 0 sw
Ra37 a da37 168796.554188576
Raterm a 0 21607224.0769795
Bcb0 cb0 0 V=floor((4095-v(code))/1)-2*floor((4095-v(code))/2)
Bnb0 nb0 0 V=1-v(cb0)
Shb0 db0 ref cb0 0 sw
Slb0 db0 0 nb0 0 sw
Rb0 b db0 21605646.344568
Bcb1 cb1 0 V=floor((4095-v(code))/2)-2*floor((4095-v(code))/4)
Bnb1 nb1 0 V=1-v(cb1)
Shb1 db1 ref cb1 0 sw
Slb1 db1 0 nb1 0 sw
Rb1 b db1 10801879.3813283
Bcb2 cb2 0 V=floor((4095-v(code))/4)-2*floor((4095-v(code))/8)
Bnb2 nb2 0 V=1-v(cb2)
Shb2 db2 ref cb2 0 sw
Slb2 db2 0 nb2 0 sw
Rb2 b db2 5400801.5728066
Bcb3 cb3 0 V=floor((4095-v(code))/8)-2*floor((4095-v(code))/16)
Bnb3 nb3 0 V=1-v(cb3)
Shb3 db3 ref cb3 0 sw
Slb3 db3 0 nb3 0 sw
Rb3 b db3 2700424.81694597
Bcb4 cb4 0 V=floor((4095-v(code))/16)-2*floor((4095-v(code))/32)
Bnb4 nb4 0 V=1-v(cb4)
Shb4 db4 ref cb4 0 sw
Slb4 db4 0 nb4 0 sw
Rb4 b db4 1350323.69617602
Bcb5 cb5 0 V=floor((4095-v(code))/32)-2*floor((4095-v(code))/64)
Bnb5 nb5 0 V=1-v(cb5)
Shb5 db5 ref cb5 0 sw
Slb5 db5 0 nb5 0 sw
Rb5 b db5 675219.947606941
Bcb6 cb6 0 V=floor((4095-v(code))/64)-2*floor((4095-v(code))/128)
Bnb6 nb6 0 V=1-v(cb6)
Shb6 db6 ref cb6 0 sw
Slb6 db6 0 nb6 0 sw
Rb6 b db6 337547.195478721
Bcb7 cb7 0 V=(floor((4095-v(code))/128)>0)
Bnb7 nb7 0 V=1-v(cb7)
Shb7 db7 ref cb7 0 sw
Slb7 db7 0 nb7 0 sw
Rb7 b db7 168801.927168949
Bcb8 cb8 0 V=(floor((4095-v(code))/128)>1)
Bnb8 nb8 0 V=1-v(cb8)
Shb8 db8 ref cb8 0 sw
Slb8 db8 0 nb8 0 sw
Rb8 b db8 168792.16423543
Bcb9 cb9 0 V=(floor((4095-v(code))/128)>2)
Bnb9 nb9 0 V=1-v(cb9)
Shb9 db9 ref cb9 0 sw
Slb9 db9 0 nb9 0 sw
Rb9 b db9 168790.739359399
Bcb10 cb10 0 V=(floor((4095-v(code))/128)>3)
Bnb10 nb10 0 V=1-v(cb10)
Shb10 db10 ref cb10 0 sw
Slb10 db10 0 nb10 0 sw
Rb10 b db10 168792.500536612
Bcb11 cb11 0 V=(floor((4095-v(code))/128)>4)
Bnb11 nb11 0 V=1-v(cb11)
Shb11 db11 ref cb11 0 sw
Slb11 db11 0 nb11 0 sw
Rb11 b db11 168807.000850689
Bcb12 cb12 0 V=(floor((4095-v(code))/128)>5)
Bnb12 nb12 0 V=1-v(cb12)
Shb12 db12 ref cb12 0 sw
Slb12 db12 0 nb12 0 sw
Rb12 b db12 168790.953030964
Bcb13 cb13 0 V=(floor((4095-v(code))/128)>6)
Bnb13 nb13 0 V=1-v(cb13)
Shb13 db13 ref cb13 0 sw
Slb13 db13 0 nb13 0 sw
Rb13 b db13 168793.794124125
Bcb14 cb14 0 V=(floor((4095-v(code))/128)>7)
Bnb14 nb14 0 V=1-v(cb14)
Shb14 db14 ref cb14 0 sw
Slb14 db14 0 nb14 0 sw
Rb14 b db14 168805.490218504
Bcb15 cb15 0 V=(floor((4095-v(code))/128)>8)
Bnb15 nb15 0 V=1-v(cb15)
Shb15 db15 ref cb15 0 sw
Slb15 db15 0 nb15 0 sw
Rb15 b db15 168797.182146308
Bcb16 cb16 0 V=(floor((4095-v(code))/128)>9)
Bnb16 nb16 0 V=1-v(cb16)
Shb16 db16 ref cb16 0 sw
Slb16 db16 0 nb16 0 sw
Rb16 b db16 168799.648718411
Bcb17 cb17 0 V=(floor((4095-v(code))/128)>10)
Bnb17 nb17 0 V=1-v(cb17)
Shb17 db17 ref cb17 0 sw
Slb17 db17 0 nb17 0 sw
Rb17 b db17 168801.510184
Bcb18 cb18 0 V=(floor((4095-v(code))/128)>11)
Bnb18 nb18 0 V=1-v(cb18)
Shb18 db18 ref cb18 0 sw
Slb18 db18 0 nb18 0 sw
Rb18 b db18 168805.293000656
Bcb19 cb19 0 V=(floor((4095-v(code))/128)>12)
Bnb19 nb19 0 V=1-v(cb19)
Shb19 db19 ref cb19 0 sw
Slb19 db19 0 nb19 0 sw
Rb19 b db19 168789.436277378
Bcb20 cb20 0 V=(floor((4095-v(code))/128)>13)
Bnb20 nb20 0 V=1-v(cb20)
Shb20 db20 ref cb20 0 sw
Slb20 db20 0 nb20 0 sw
Rb20 b db20 168779.818188016
Bcb21 cb21 0 V=(floor((4095-v(code))/128)>14)
Bnb21 nb21 0 V=1-v(cb21)
Shb21 db21 ref cb21 0 sw
Slb21 db21 0 nb21 0 sw
Rb21 b db21 168789.874258367
Bcb22 cb22 0 V=(floor((4095-v(code))/128)>15)
Bnb22 nb22 0 V=1-v(cb22)
Shb22 db22 ref cb22 0 sw
Slb22 db22 0 nb22 0 sw
Rb22 b db22 168791.142300126
Bcb23 cb23 0 V=(floor((4095-v(code))/128)>16)
Bnb23 nb23 0 V=1-v(cb23)
Shb23 db23 ref cb23 0 sw
Slb23 db23 0 nb23 0 sw
Rb23 b db23 168786.372986096
Bcb24 cb24 0 V=(floor((4095-v(code))/128)>17)
Bnb24 nb24 0 V=1-v(cb24)
Shb24 db24 ref cb24 0 sw
Slb24 db24 0 nb24 0 sw
Rb24 b db24 168789.981611712
Bcb25 cb25 0 V=(floor((4095-v(code))/128)>18)
Bnb25 nb25 0 V=1-v(cb25)
Shb25 db25 ref cb25 0 sw
Slb25 db25 0 nb25 0 sw
Rb25 b db25 168784.655197038
Bcb26 cb26 0 V=(floor((4095-v(code))/128)>19)
Bnb26 nb26 0 V=1-v(cb26)
Shb26 db26 ref cb26 0 sw
Slb26 db26 0 nb26 0 sw
Rb26 b db26 168791.037115482
Bcb27 cb27 0 V=(floor((4095-v(code))/128)>20)
Bnb27 nb27 0 V=1-v(cb27)
Shb27 db27 ref cb27 0 sw
Slb27 db27 0 nb27 0 sw
Rb27 b db27 168801.278873094
Bcb28 cb28 0 V=(floor((4095-v(code))/128)>21)
Bnb28 nb28 0 V=1-v(cb28)
Shb28 db28 ref cb28 0 sw
Slb28 db28 0 nb28 0 sw
Rb28 b db28 168794.855623545
Bcb29 cb29 0 V=(floor((4095-v(code))/128)>22)
Bnb29 nb29 0 V=1-v(cb29)
Shb29 db29 ref cb29 0 sw
Slb29 db29 0 nb29 0 sw
Rb29 b db29 168786.090380406
Bcb30 cb30 0 V=(floor((4095-v(code))/128)>23)
Bnb30 nb30 0 V=1-v(cb30)
Shb30 db30 ref cb30 0 sw
Slb30 db30 0 nb30 0 sw
Rb30 b db30 168788.942950674
Bcb31 cb31 0 V=(floor((4095-v(code))/128)>24)
Bnb31 nb31 0 V=1-v(cb31)
Shb31 db31 ref cb31 0 sw
Slb31 db31 0 nb31 0 sw
Rb31 b db31 168782.88004338
Bcb32 cb32 0 V=(floor((4095-v(code))/128)>25)
Bnb32 nb32 0 V=1-v(cb32)
Shb32 db32 ref cb32 0 sw
Slb32 db32 0 nb32 0 sw
Rb32 b db32 168777.252827687
Bcb33 cb33 0 V=(floor((4095-v(code))/128)>26)
Bnb33 nb33 0 V=1-v(cb33)
Shb33 db33 ref cb33 0 sw
Slb33 db33 0 nb33 0 sw
Rb33 b db33 168789.451107204
Bcb34 cb34 0 V=(floor((4095-v(code))/128)>27)
Bnb34 nb34 0 V=1-v(cb34)
Shb34 db34 ref cb34 0 sw
Slb34 db34 0 nb34 0 sw
Rb34 b db34 168789.768040726
Bcb35 cb35 0 V=(floor((4095-v(code))/128)>28)
Bnb35 nb35 0 V=1-v(cb35)
Shb35 db35 ref cb35 0 sw
Slb35 db35 0 nb35 0 sw
Rb35 b db35 168783.259326315
Bcb36 cb36 0 V=(floor((4095-v(code))/128)>29)
Bnb36 nb36 0 V=1-v(cb36)
Shb36 db36 ref cb36 0 sw
Slb36 db36 0 nb36 0 sw
Rb36 b db36 168778.318667734
Bcb37 cb37 0 V=(floor((4095-v(code))/128)>30)
Bnb37 nb37 0 V=1-v(cb37)
Shb37 db37 ref cb37 0 sw
Slb37 db37 0 nb37 0 sw
Rb37 b db37 168782.663214542
Rbterm b 0 21603452.8538188
Rload a b 10000.0
.dc Vcode 0 4095 1
.end
