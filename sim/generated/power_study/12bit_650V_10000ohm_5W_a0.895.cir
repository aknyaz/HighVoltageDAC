Scaled 5 V R-2R power-study verification
Vref ref 0 5
.model ideal SW(Ron=1u Roff=1e12 Vt=.5 Vh=0)
.options reltol=1e-7 abstol=1e-13
Va0 ca0 0 PWL(0 1 2.08333333333e-05 1 2.08343333333e-05 0 3.64583333333e-05 0 3.64593333333e-05 1 4.6875e-05 1 4.6876e-05 0 5.20833333333e-05 0 5.20843333333e-05 1 6.25e-05 1 6.2501e-05 0 6.77083333333e-05 0 6.77093333333e-05 1 7.8125e-05 1 7.8126e-05 0 8.85416666667e-05 0 8.85426666667e-05 1 9.375e-05 1 9.3751e-05 0 9.89583333333e-05 0 9.89593333333e-05 1 0.000114583333333 1 0.000114584333333 0 0.000130208333333 0 0.000130209333333 1 0.000151041666667 1 0.000151042666667 0 0.000161458333333 0 0.000161459333333 1 0.000171875 1 0.000171876 0 0.000182291666667 0 0.000182292666667 1 0.0001875 1 0.000187501 0 0.000192708333333 0 0.000192709333333 1 0.000197916666667 1 0.000197917666667 0 0.000208333333333 0 0.000208334333333 1 0.00021875 1 0.000218751 0 0.00028125 0 0.000281251 1 0.000291666666667 1 0.000291667666667 0 0.000302083333333 0 0.000302084333333 1 0.000307291666667 1 0.000307292666667 0 0.0003125 0 0.000312501 1 0.000317708333333 1 0.000317709333333 0 0.000328125 0 0.000328126 1 0.000338541666667 1 0.000338542666667 0 0.000348958333333 0 0.000348959333333 1 0.000369791666667 1 0.000369792666667 0 0.000385416666667 0 0.000385417666667 1 0.000401041666667 1 0.000401042666667 0 0.00040625 0 0.000406251 1 0.000411458333333 1 0.000411459333333 0 0.000421875 0 0.000421876 1 0.000432291666667 1 0.000432292666667 0 0.0004375 0 0.000437501 1 0.000447916666667 1 0.000447917666667 0 0.000453125 0 0.000453126 1 0.000463541666667 1 0.000463542666667 0 0.000479166666667 0 0.000479167666667 1 0.0005 1 0.000500001 0 0.000520833333333 0 0.000520834333333 1 0.000536458333333 1 0.000536459333333 0 0.000546875 0 0.000546876 1 0.000552083333333 1 0.000552084333333 0 0.0005625 0 0.000562501 1 0.000567708333333 1 0.000567709333333 0 0.000578125 0 0.000578126 1 0.000588541666667 1 0.000588542666667 0 0.00059375 0 0.000593751 1 0.000598958333333 1 0.000598959333333 0 0.000614583333333 0 0.000614584333333 1 0.000630208333333 1 0.000630209333333 0 0.000651041666667 0 0.000651042666667 1 0.000661458333333 1 0.000661459333333 0 0.000671875 0 0.000671876 1 0.000682291666667 1 0.000682292666667 0 0.0006875 0 0.000687501 1 0.000692708333333 1 0.000692709333333 0 0.000697916666667 0 0.000697917666667 1 0.000708333333333 1 0.000708334333333 0 0.00071875 0 0.000718751 1 0.00078125 1 0.000781251 0 0.000791666666667 0 0.000791667666667 1 0.000802083333333 1 0.000802084333333 0 0.000807291666667 0 0.000807292666667 1 0.0008125 1 0.000812501 0 0.000817708333333 0 0.000817709333333 1 0.000828125 1 0.000828126 0 0.000838541666667 0 0.000838542666667 1 0.000848958333333 1 0.000848959333333 0 0.000869791666667 0 0.000869792666667 1 0.000885416666667 1 0.000885417666667 0 0.000901041666667 0 0.000901042666667 1 0.00090625 1 0.000906251 0 0.000911458333333 0 0.000911459333333 1 0.000921875 1 0.000921876 0 0.000932291666667 0 0.000932292666667 1 0.0009375 1 0.000937501 0 0.000947916666667 0 0.000947917666667 1 0.000953125 1 0.000953126 0 0.000963541666667 0 0.000963542666667 1 0.000979166666667 1 0.000979167666667 0)
Ba0 na0 0 V=1-v(ca0)
Sa0h da0 ref ca0 0 ideal
Sa0l da0 0 na0 0 ideal
Ra0v a0 da0 8391.53385982
Va1 ca1 0 PWL(0 0 3.125e-05 0 3.1251e-05 1 3.64583333333e-05 1 3.64593333333e-05 0 4.16666666667e-05 0 4.16676666667e-05 1 4.6875e-05 1 4.6876e-05 0 6.77083333333e-05 0 6.77093333333e-05 1 7.29166666667e-05 1 7.29176666667e-05 0 7.8125e-05 0 7.8126e-05 1 8.85416666667e-05 1 8.85426666667e-05 0 9.375e-05 0 9.3751e-05 1 0.000109375 1 0.000109376 0 0.000114583333333 0 0.000114584333333 1 0.000125 1 0.000125001 0 0.000140625 0 0.000140626 1 0.00015625 1 0.000156251 0 0.000161458333333 0 0.000161459333333 1 0.000166666666667 1 0.000166667666667 0 0.000171875 0 0.000171876 1 0.000177083333333 1 0.000177084333333 0 0.000203125 0 0.000203126 1 0.000208333333333 1 0.000208334333333 0 0.000213541666667 0 0.000213542666667 1 0.000223958333333 1 0.000223959333333 0 0.000234375 0 0.000234376 1 0.000244791666667 1 0.000244792666667 0 0.000255208333333 0 0.000255209333333 1 0.000265625 1 0.000265626 0 0.000276041666667 0 0.000276042666667 1 0.000286458333333 1 0.000286459333333 0 0.000291666666667 0 0.000291667666667 1 0.000296875 1 0.000296876 0 0.000322916666667 0 0.000322917666667 1 0.000328125 1 0.000328126 0 0.000333333333333 0 0.000333334333333 1 0.000338541666667 1 0.000338542666667 0 0.00034375 0 0.000343751 1 0.000359375 1 0.000359376 0 0.000375 0 0.000375001 1 0.000385416666667 1 0.000385417666667 0 0.000390625 0 0.000390626 1 0.00040625 1 0.000406251 0 0.000411458333333 0 0.000411459333333 1 0.000421875 1 0.000421876 0 0.000427083333333 0 0.000427084333333 1 0.000432291666667 1 0.000432292666667 0 0.000453125 0 0.000453126 1 0.000458333333333 1 0.000458334333333 0 0.000463541666667 0 0.000463542666667 1 0.00046875 1 0.000468751 0 0.0005 0 0.000500001 1 0.00053125 1 0.000531251 0 0.000536458333333 0 0.000536459333333 1 0.000541666666667 1 0.000541667666667 0 0.000546875 0 0.000546876 1 0.000567708333333 1 0.000567709333333 0 0.000572916666667 0 0.000572917666667 1 0.000578125 1 0.000578126 0 0.000588541666667 0 0.000588542666667 1 0.00059375 1 0.000593751 0 0.000609375 0 0.000609376 1 0.000614583333333 1 0.000614584333333 0 0.000625 0 0.000625001 1 0.000640625 1 0.000640626 0 0.00065625 0 0.000656251 1 0.000661458333333 1 0.000661459333333 0 0.000666666666667 0 0.000666667666667 1 0.000671875 1 0.000671876 0 0.000677083333333 0 0.000677084333333 1 0.000703125 1 0.000703126 0 0.000708333333333 0 0.000708334333333 1 0.000713541666667 1 0.000713542666667 0 0.000723958333333 0 0.000723959333333 1 0.000734375 1 0.000734376 0 0.000744791666667 0 0.000744792666667 1 0.000755208333333 1 0.000755209333333 0 0.000765625 0 0.000765626 1 0.000776041666667 1 0.000776042666667 0 0.000786458333333 0 0.000786459333333 1 0.000791666666667 1 0.000791667666667 0 0.000796875 0 0.000796876 1 0.000822916666667 1 0.000822917666667 0 0.000828125 0 0.000828126 1 0.000833333333333 1 0.000833334333333 0 0.000838541666667 0 0.000838542666667 1 0.00084375 1 0.000843751 0 0.000859375 0 0.000859376 1 0.000875 1 0.000875001 0 0.000885416666667 0 0.000885417666667 1 0.000890625 1 0.000890626 0 0.00090625 0 0.000906251 1 0.000911458333333 1 0.000911459333333 0 0.000921875 0 0.000921876 1 0.000927083333333 1 0.000927084333333 0 0.000932291666667 0 0.000932292666667 1 0.000953125 1 0.000953126 0 0.000958333333333 0 0.000958334333333 1 0.000963541666667 1 0.000963542666667 0 0.00096875 0 0.000968751 1)
Ba1 na1 0 V=1-v(ca1)
Sa1h da1 ref ca1 0 ideal
Sa1l da1 0 na1 0 ideal
Ra1v a1 da1 8391.53385982
Ra1h a1 a0 4195.76692991
Va2 ca2 0 PWL(0 1 5.20833333333e-06 1 5.20933333333e-06 0 1.04166666667e-05 0 1.04176666667e-05 1 1.5625e-05 1 1.5626e-05 0 2.08333333333e-05 0 2.08343333333e-05 1 2.60416666667e-05 1 2.60426666667e-05 0 3.64583333333e-05 0 3.64593333333e-05 1 4.6875e-05 1 4.6876e-05 0 6.77083333333e-05 0 6.77093333333e-05 1 7.8125e-05 1 7.8126e-05 0 8.33333333333e-05 0 8.33343333333e-05 1 8.85416666667e-05 1 8.85426666667e-05 0 0.000114583333333 0 0.000114584333333 1 0.000119791666667 1 0.000119792666667 0 0.000125 0 0.000125001 1 0.000140625 1 0.000140626 0 0.000145833333333 0 0.000145834333333 1 0.000151041666667 1 0.000151042666667 0 0.00015625 0 0.000156251 1 0.000161458333333 1 0.000161459333333 0 0.000171875 0 0.000171876 1 0.000177083333333 1 0.000177084333333 0 0.000192708333333 0 0.000192709333333 1 0.000197916666667 1 0.000197917666667 0 0.000213541666667 0 0.000213542666667 1 0.00021875 1 0.000218751 0 0.000223958333333 0 0.000223959333333 1 0.000234375 1 0.000234376 0 0.000239583333333 0 0.000239584333333 1 0.000244791666667 1 0.000244792666667 0 0.000255208333333 0 0.000255209333333 1 0.000260416666667 1 0.000260417666667 0 0.000265625 0 0.000265626 1 0.000276041666667 1 0.000276042666667 0 0.00028125 0 0.000281251 1 0.000286458333333 1 0.000286459333333 0 0.000302083333333 0 0.000302084333333 1 0.000307291666667 1 0.000307292666667 0 0.000322916666667 0 0.000322917666667 1 0.000328125 1 0.000328126 0 0.000338541666667 0 0.000338542666667 1 0.00034375 1 0.000343751 0 0.000348958333333 0 0.000348959333333 1 0.000354166666667 1 0.000354167666667 0 0.000359375 0 0.000359376 1 0.000375 1 0.000375001 0 0.000380208333333 0 0.000380209333333 1 0.000385416666667 1 0.000385417666667 0 0.000411458333333 0 0.000411459333333 1 0.000416666666667 1 0.000416667666667 0 0.000421875 0 0.000421876 1 0.000432291666667 1 0.000432292666667 0 0.000453125 0 0.000453126 1 0.000463541666667 1 0.000463542666667 0 0.000473958333333 0 0.000473959333333 1 0.000479166666667 1 0.000479167666667 0 0.000484375 0 0.000484376 1 0.000489583333333 1 0.000489584333333 0 0.000494791666667 0 0.000494792666667 1 0.0005 1 0.000500001 0 0.000505208333333 0 0.000505209333333 1 0.000510416666667 1 0.000510417666667 0 0.000515625 0 0.000515626 1 0.000520833333333 1 0.000520834333333 0 0.000526041666667 0 0.000526042666667 1 0.000536458333333 1 0.000536459333333 0 0.000546875 0 0.000546876 1 0.000567708333333 1 0.000567709333333 0 0.000578125 0 0.000578126 1 0.000583333333333 1 0.000583334333333 0 0.000588541666667 0 0.000588542666667 1 0.000614583333333 1 0.000614584333333 0 0.000619791666667 0 0.000619792666667 1 0.000625 1 0.000625001 0 0.000640625 0 0.000640626 1 0.000645833333333 1 0.000645834333333 0 0.000651041666667 0 0.000651042666667 1 0.00065625 1 0.000656251 0 0.000661458333333 0 0.000661459333333 1 0.000671875 1 0.000671876 0 0.000677083333333 0 0.000677084333333 1 0.000692708333333 1 0.000692709333333 0 0.000697916666667 0 0.000697917666667 1 0.000713541666667 1 0.000713542666667 0 0.00071875 0 0.000718751 1 0.000723958333333 1 0.000723959333333 0 0.000734375 0 0.000734376 1 0.000739583333333 1 0.000739584333333 0 0.000744791666667 0 0.000744792666667 1 0.000755208333333 1 0.000755209333333 0 0.000760416666667 0 0.000760417666667 1 0.000765625 1 0.000765626 0 0.000776041666667 0 0.000776042666667 1 0.00078125 1 0.000781251 0 0.000786458333333 0 0.000786459333333 1 0.000802083333333 1 0.000802084333333 0 0.000807291666667 0 0.000807292666667 1 0.000822916666667 1 0.000822917666667 0 0.000828125 0 0.000828126 1 0.000838541666667 1 0.000838542666667 0 0.00084375 0 0.000843751 1 0.000848958333333 1 0.000848959333333 0 0.000854166666667 0 0.000854167666667 1 0.000859375 1 0.000859376 0 0.000875 0 0.000875001 1 0.000880208333333 1 0.000880209333333 0 0.000885416666667 0 0.000885417666667 1 0.000911458333333 1 0.000911459333333 0 0.000916666666667 0 0.000916667666667 1 0.000921875 1 0.000921876 0 0.000932291666667 0 0.000932292666667 1 0.000953125 1 0.000953126 0 0.000963541666667 0 0.000963542666667 1 0.000973958333333 1 0.000973959333333 0 0.000979166666667 0 0.000979167666667 1 0.000984375 1 0.000984376 0 0.000989583333333 0 0.000989584333333 1 0.000994791666667 1 0.000994792666667 0)
Ba2 na2 0 V=1-v(ca2)
Sa2h da2 ref ca2 0 ideal
Sa2l da2 0 na2 0 ideal
Ra2v a2 da2 8391.53385982
Ra2h a2 a1 4195.76692991
Va3 ca3 0 PWL(0 1 1.04166666667e-05 1 1.04176666667e-05 0 2.08333333333e-05 0 2.08343333333e-05 1 3.125e-05 1 3.1251e-05 0 3.64583333333e-05 0 3.64593333333e-05 1 4.16666666667e-05 1 4.16676666667e-05 0 5.20833333333e-05 0 5.20843333333e-05 1 5.72916666667e-05 1 5.72926666667e-05 0 6.25e-05 0 6.2501e-05 1 7.29166666667e-05 1 7.29176666667e-05 0 7.8125e-05 0 7.8126e-05 1 8.85416666667e-05 1 8.85426666667e-05 0 0.000114583333333 0 0.000114584333333 1 0.000125 1 0.000125001 0 0.000130208333333 0 0.000130209333333 1 0.000135416666667 1 0.000135417666667 0 0.000140625 0 0.000140626 1 0.000151041666667 1 0.000151042666667 0 0.000171875 0 0.000171876 1 0.000182291666667 1 0.000182292666667 0 0.0001875 0 0.000187501 1 0.000197916666667 1 0.000197917666667 0 0.000213541666667 0 0.000213542666667 1 0.000223958333333 1 0.000223959333333 0 0.000229166666667 0 0.000229167666667 1 0.000234375 1 0.000234376 0 0.000244791666667 0 0.000244792666667 1 0.000255208333333 1 0.000255209333333 0 0.000265625 0 0.000265626 1 0.000270833333333 1 0.000270834333333 0 0.000276041666667 0 0.000276042666667 1 0.000286458333333 1 0.000286459333333 0 0.000302083333333 0 0.000302084333333 1 0.0003125 1 0.000312501 0 0.000317708333333 0 0.000317709333333 1 0.000328125 1 0.000328126 0 0.000348958333333 0 0.000348959333333 1 0.000359375 1 0.000359376 0 0.000364583333333 0 0.000364584333333 1 0.000369791666667 1 0.000369792666667 0 0.000375 0 0.000375001 1 0.000385416666667 1 0.000385417666667 0 0.000411458333333 0 0.000411459333333 1 0.000421875 1 0.000421876 0 0.000427083333333 0 0.000427084333333 1 0.0004375 1 0.000437501 0 0.000442708333333 0 0.000442709333333 1 0.000447916666667 1 0.000447917666667 0 0.000458333333333 0 0.000458334333333 1 0.000463541666667 1 0.000463542666667 0 0.00046875 0 0.000468751 1 0.000479166666667 1 0.000479167666667 0 0.000489583333333 0 0.000489584333333 1 0.0005 1 0.000500001 0 0.000510416666667 0 0.000510417666667 1 0.000520833333333 1 0.000520834333333 0 0.00053125 0 0.000531251 1 0.000536458333333 1 0.000536459333333 0 0.000541666666667 0 0.000541667666667 1 0.000552083333333 1 0.000552084333333 0 0.000557291666667 0 0.000557292666667 1 0.0005625 1 0.000562501 0 0.000572916666667 0 0.000572917666667 1 0.000578125 1 0.000578126 0 0.000588541666667 0 0.000588542666667 1 0.000614583333333 1 0.000614584333333 0 0.000625 0 0.000625001 1 0.000630208333333 1 0.000630209333333 0 0.000635416666667 0 0.000635417666667 1 0.000640625 1 0.000640626 0 0.000651041666667 0 0.000651042666667 1 0.000671875 1 0.000671876 0 0.000682291666667 0 0.000682292666667 1 0.0006875 1 0.000687501 0 0.000697916666667 0 0.000697917666667 1 0.000713541666667 1 0.000713542666667 0 0.000723958333333 0 0.000723959333333 1 0.000729166666667 1 0.000729167666667 0 0.000734375 0 0.000734376 1 0.000744791666667 1 0.000744792666667 0 0.000755208333333 0 0.000755209333333 1 0.000765625 1 0.000765626 0 0.000770833333333 0 0.000770834333333 1 0.000776041666667 1 0.000776042666667 0 0.000786458333333 0 0.000786459333333 1 0.000802083333333 1 0.000802084333333 0 0.0008125 0 0.000812501 1 0.000817708333333 1 0.000817709333333 0 0.000828125 0 0.000828126 1 0.000848958333333 1 0.000848959333333 0 0.000859375 0 0.000859376 1 0.000864583333333 1 0.000864584333333 0 0.000869791666667 0 0.000869792666667 1 0.000875 1 0.000875001 0 0.000885416666667 0 0.000885417666667 1 0.000911458333333 1 0.000911459333333 0 0.000921875 0 0.000921876 1 0.000927083333333 1 0.000927084333333 0 0.0009375 0 0.000937501 1 0.000942708333333 1 0.000942709333333 0 0.000947916666667 0 0.000947917666667 1 0.000958333333333 1 0.000958334333333 0 0.000963541666667 0 0.000963542666667 1 0.00096875 1 0.000968751 0 0.000979166666667 0 0.000979167666667 1 0.000989583333333 1 0.000989584333333 0)
Ba3 na3 0 V=1-v(ca3)
Sa3h da3 ref ca3 0 ideal
Sa3l da3 0 na3 0 ideal
Ra3v a3 da3 8391.53385982
Ra3h a3 a2 4195.76692991
Va4 ca4 0 PWL(0 1 2.08333333333e-05 1 2.08343333333e-05 0 3.64583333333e-05 0 3.64593333333e-05 1 5.20833333333e-05 1 5.20843333333e-05 0 6.25e-05 0 6.2501e-05 1 6.77083333333e-05 1 6.77093333333e-05 0 7.8125e-05 0 7.8126e-05 1 8.33333333333e-05 1 8.33343333333e-05 0 9.375e-05 0 9.3751e-05 1 9.89583333333e-05 1 9.89593333333e-05 0 0.000104166666667 0 0.000104167666667 1 0.000109375 1 0.000109376 0 0.000119791666667 0 0.000119792666667 1 0.000125 1 0.000125001 0 0.000135416666667 0 0.000135417666667 1 0.000151041666667 1 0.000151042666667 0 0.000171875 0 0.000171876 1 0.0001875 1 0.000187501 0 0.000192708333333 0 0.000192709333333 1 0.000203125 1 0.000203126 0 0.000208333333333 0 0.000208334333333 1 0.00021875 1 0.000218751 0 0.000223958333333 0 0.000223959333333 1 0.000234375 1 0.000234376 0 0.000265625 0 0.000265626 1 0.000276041666667 1 0.000276042666667 0 0.00028125 0 0.000281251 1 0.000291666666667 1 0.000291667666667 0 0.000296875 0 0.000296876 1 0.000307291666667 1 0.000307292666667 0 0.0003125 0 0.000312501 1 0.000328125 1 0.000328126 0 0.000348958333333 0 0.000348959333333 1 0.000364583333333 1 0.000364584333333 0 0.000375 0 0.000375001 1 0.000380208333333 1 0.000380209333333 0 0.000390625 0 0.000390626 1 0.000395833333333 1 0.000395834333333 0 0.000401041666667 0 0.000401042666667 1 0.00040625 1 0.000406251 0 0.000416666666667 0 0.000416667666667 1 0.000421875 1 0.000421876 0 0.000432291666667 0 0.000432292666667 1 0.0004375 1 0.000437501 0 0.000447916666667 0 0.000447917666667 1 0.000463541666667 1 0.000463542666667 0 0.000479166666667 0 0.000479167666667 1 0.0005 1 0.000500001 0 0.000520833333333 0 0.000520834333333 1 0.000536458333333 1 0.000536459333333 0 0.000552083333333 0 0.000552084333333 1 0.0005625 1 0.000562501 0 0.000567708333333 0 0.000567709333333 1 0.000578125 1 0.000578126 0 0.000583333333333 0 0.000583334333333 1 0.00059375 1 0.000593751 0 0.000598958333333 0 0.000598959333333 1 0.000604166666667 1 0.000604167666667 0 0.000609375 0 0.000609376 1 0.000619791666667 1 0.000619792666667 0 0.000625 0 0.000625001 1 0.000635416666667 1 0.000635417666667 0 0.000651041666667 0 0.000651042666667 1 0.000671875 1 0.000671876 0 0.0006875 0 0.000687501 1 0.000692708333333 1 0.000692709333333 0 0.000703125 0 0.000703126 1 0.000708333333333 1 0.000708334333333 0 0.00071875 0 0.000718751 1 0.000723958333333 1 0.000723959333333 0 0.000734375 0 0.000734376 1 0.000765625 1 0.000765626 0 0.000776041666667 0 0.000776042666667 1 0.00078125 1 0.000781251 0 0.000791666666667 0 0.000791667666667 1 0.000796875 1 0.000796876 0 0.000807291666667 0 0.000807292666667 1 0.0008125 1 0.000812501 0 0.000828125 0 0.000828126 1 0.000848958333333 1 0.000848959333333 0 0.000864583333333 0 0.000864584333333 1 0.000875 1 0.000875001 0 0.000880208333333 0 0.000880209333333 1 0.000890625 1 0.000890626 0 0.000895833333333 0 0.000895834333333 1 0.000901041666667 1 0.000901042666667 0 0.00090625 0 0.000906251 1 0.000916666666667 1 0.000916667666667 0 0.000921875 0 0.000921876 1 0.000932291666667 1 0.000932292666667 0 0.0009375 0 0.000937501 1 0.000947916666667 1 0.000947917666667 0 0.000963541666667 0 0.000963542666667 1 0.000979166666667 1 0.000979167666667 0)
Ba4 na4 0 V=1-v(ca4)
Sa4h da4 ref ca4 0 ideal
Sa4l da4 0 na4 0 ideal
Ra4v a4 da4 8391.53385982
Ra4h a4 a3 4195.76692991
Va5 ca5 0 PWL(0 0 3.64583333333e-05 0 3.64593333333e-05 1 6.25e-05 1 6.2501e-05 0 7.8125e-05 0 7.8126e-05 1 9.375e-05 1 9.3751e-05 0 0.000104166666667 0 0.000104167666667 1 0.000114583333333 1 0.000114584333333 0 0.000119791666667 0 0.000119792666667 1 0.000130208333333 1 0.000130209333333 0 0.000135416666667 0 0.000135417666667 1 0.000140625 1 0.000140626 0 0.000145833333333 0 0.000145834333333 1 0.00015625 1 0.000156251 0 0.000161458333333 0 0.000161459333333 1 0.000166666666667 1 0.000166667666667 0 0.000177083333333 0 0.000177084333333 1 0.000182291666667 1 0.000182292666667 0 0.0001875 0 0.000187501 1 0.000197916666667 1 0.000197917666667 0 0.000203125 0 0.000203126 1 0.00021875 1 0.000218751 0 0.000234375 0 0.000234376 1 0.000265625 1 0.000265626 0 0.00028125 0 0.000281251 1 0.000296875 1 0.000296876 0 0.000302083333333 0 0.000302084333333 1 0.0003125 1 0.000312501 0 0.000317708333333 0 0.000317709333333 1 0.000322916666667 1 0.000322917666667 0 0.000333333333333 0 0.000333334333333 1 0.000338541666667 1 0.000338542666667 0 0.00034375 0 0.000343751 1 0.000354166666667 1 0.000354167666667 0 0.000359375 0 0.000359376 1 0.000364583333333 1 0.000364584333333 0 0.000369791666667 0 0.000369792666667 1 0.000380208333333 1 0.000380209333333 0 0.000385416666667 0 0.000385417666667 1 0.000395833333333 1 0.000395834333333 0 0.00040625 0 0.000406251 1 0.000421875 1 0.000421876 0 0.0004375 0 0.000437501 1 0.000463541666667 1 0.000463542666667 0 0.0005 0 0.000500001 1 0.000536458333333 1 0.000536459333333 0 0.0005625 0 0.000562501 1 0.000578125 1 0.000578126 0 0.00059375 0 0.000593751 1 0.000604166666667 1 0.000604167666667 0 0.000614583333333 0 0.000614584333333 1 0.000619791666667 1 0.000619792666667 0 0.000630208333333 0 0.000630209333333 1 0.000635416666667 1 0.000635417666667 0 0.000640625 0 0.000640626 1 0.000645833333333 1 0.000645834333333 0 0.00065625 0 0.000656251 1 0.000661458333333 1 0.000661459333333 0 0.000666666666667 0 0.000666667666667 1 0.000677083333333 1 0.000677084333333 0 0.000682291666667 0 0.000682292666667 1 0.0006875 1 0.000687501 0 0.000697916666667 0 0.000697917666667 1 0.000703125 1 0.000703126 0 0.00071875 0 0.000718751 1 0.000734375 1 0.000734376 0 0.000765625 0 0.000765626 1 0.00078125 1 0.000781251 0 0.000796875 0 0.000796876 1 0.000802083333333 1 0.000802084333333 0 0.0008125 0 0.000812501 1 0.000817708333333 1 0.000817709333333 0 0.000822916666667 0 0.000822917666667 1 0.000833333333333 1 0.000833334333333 0 0.000838541666667 0 0.000838542666667 1 0.00084375 1 0.000843751 0 0.000854166666667 0 0.000854167666667 1 0.000859375 1 0.000859376 0 0.000864583333333 0 0.000864584333333 1 0.000869791666667 1 0.000869792666667 0 0.000880208333333 0 0.000880209333333 1 0.000885416666667 1 0.000885417666667 0 0.000895833333333 0 0.000895834333333 1 0.00090625 1 0.000906251 0 0.000921875 0 0.000921876 1 0.0009375 1 0.000937501 0 0.000963541666667 0 0.000963542666667 1)
Ba5 na5 0 V=1-v(ca5)
Sa5h da5 ref ca5 0 ideal
Sa5l da5 0 na5 0 ideal
Ra5v a5 da5 8391.53385982
Ra5h a5 a4 4195.76692991
Va6 ca6 0 PWL(0 0 5.20833333333e-06 0 5.20933333333e-06 1 1.04166666667e-05 1 1.04176666667e-05 0 1.5625e-05 0 1.5626e-05 1 2.08333333333e-05 1 2.08343333333e-05 0 2.60416666667e-05 0 2.60426666667e-05 1 3.125e-05 1 3.1251e-05 0 4.16666666667e-05 0 4.16676666667e-05 1 4.6875e-05 1 4.6876e-05 0 5.20833333333e-05 0 5.20843333333e-05 1 5.72916666667e-05 1 5.72926666667e-05 0 6.25e-05 0 6.2501e-05 1 6.77083333333e-05 1 6.77093333333e-05 0 7.29166666667e-05 0 7.29176666667e-05 1 8.33333333333e-05 1 8.33343333333e-05 0 8.85416666667e-05 0 8.85426666667e-05 1 9.375e-05 1 9.3751e-05 0 9.89583333333e-05 0 9.89593333333e-05 1 0.000109375 1 0.000109376 0 0.000114583333333 0 0.000114584333333 1 0.000125 1 0.000125001 0 0.000130208333333 0 0.000130209333333 1 0.000140625 1 0.000140626 0 0.000151041666667 0 0.000151042666667 1 0.00015625 1 0.000156251 0 0.000166666666667 0 0.000166667666667 1 0.000182291666667 1 0.000182292666667 0 0.000197916666667 0 0.000197917666667 1 0.00021875 1 0.000218751 0 0.00028125 0 0.000281251 1 0.000302083333333 1 0.000302084333333 0 0.000317708333333 0 0.000317709333333 1 0.000333333333333 1 0.000333334333333 0 0.00034375 0 0.000343751 1 0.000348958333333 1 0.000348959333333 0 0.000359375 0 0.000359376 1 0.000369791666667 1 0.000369792666667 0 0.000375 0 0.000375001 1 0.000385416666667 1 0.000385417666667 0 0.000390625 0 0.000390626 1 0.000401041666667 1 0.000401042666667 0 0.00040625 0 0.000406251 1 0.000411458333333 1 0.000411459333333 0 0.000416666666667 0 0.000416667666667 1 0.000427083333333 1 0.000427084333333 0 0.000432291666667 0 0.000432292666667 1 0.0004375 1 0.000437501 0 0.000442708333333 0 0.000442709333333 1 0.000447916666667 1 0.000447917666667 0 0.000453125 0 0.000453126 1 0.000458333333333 1 0.000458334333333 0 0.00046875 0 0.000468751 1 0.000473958333333 1 0.000473959333333 0 0.000479166666667 0 0.000479167666667 1 0.000484375 1 0.000484376 0 0.000489583333333 0 0.000489584333333 1 0.000494791666667 1 0.000494792666667 0 0.0005 0 0.000500001 1 0.000505208333333 1 0.000505209333333 0 0.000510416666667 0 0.000510417666667 1 0.000515625 1 0.000515626 0 0.000520833333333 0 0.000520834333333 1 0.000526041666667 1 0.000526042666667 0 0.00053125 0 0.000531251 1 0.000541666666667 1 0.000541667666667 0 0.000546875 0 0.000546876 1 0.000552083333333 1 0.000552084333333 0 0.000557291666667 0 0.000557292666667 1 0.0005625 1 0.000562501 0 0.000567708333333 0 0.000567709333333 1 0.000572916666667 1 0.000572917666667 0 0.000583333333333 0 0.000583334333333 1 0.000588541666667 1 0.000588542666667 0 0.00059375 0 0.000593751 1 0.000598958333333 1 0.000598959333333 0 0.000609375 0 0.000609376 1 0.000614583333333 1 0.000614584333333 0 0.000625 0 0.000625001 1 0.000630208333333 1 0.000630209333333 0 0.000640625 0 0.000640626 1 0.000651041666667 1 0.000651042666667 0 0.00065625 0 0.000656251 1 0.000666666666667 1 0.000666667666667 0 0.000682291666667 0 0.000682292666667 1 0.000697916666667 1 0.000697917666667 0 0.00071875 0 0.000718751 1 0.00078125 1 0.000781251 0 0.000802083333333 0 0.000802084333333 1 0.000817708333333 1 0.000817709333333 0 0.000833333333333 0 0.000833334333333 1 0.00084375 1 0.000843751 0 0.000848958333333 0 0.000848959333333 1 0.000859375 1 0.000859376 0 0.000869791666667 0 0.000869792666667 1 0.000875 1 0.000875001 0 0.000885416666667 0 0.000885417666667 1 0.000890625 1 0.000890626 0 0.000901041666667 0 0.000901042666667 1 0.00090625 1 0.000906251 0 0.000911458333333 0 0.000911459333333 1 0.000916666666667 1 0.000916667666667 0 0.000927083333333 0 0.000927084333333 1 0.000932291666667 1 0.000932292666667 0 0.0009375 0 0.000937501 1 0.000942708333333 1 0.000942709333333 0 0.000947916666667 0 0.000947917666667 1 0.000953125 1 0.000953126 0 0.000958333333333 0 0.000958334333333 1 0.00096875 1 0.000968751 0 0.000973958333333 0 0.000973959333333 1 0.000979166666667 1 0.000979167666667 0 0.000984375 0 0.000984376 1 0.000989583333333 1 0.000989584333333 0 0.000994791666667 0 0.000994792666667 1)
Ba6 na6 0 V=1-v(ca6)
Sa6h da6 ref ca6 0 ideal
Sa6l da6 0 na6 0 ideal
Ra6v a6 da6 8391.53385982
Ra6h a6 a5 4195.76692991
Va7 ca7 0 PWL(0 0 1.04166666667e-05 0 1.04176666667e-05 1 2.08333333333e-05 1 2.08343333333e-05 0 3.125e-05 0 3.1251e-05 1 4.6875e-05 1 4.6876e-05 0 5.72916666667e-05 0 5.72926666667e-05 1 6.77083333333e-05 1 6.77093333333e-05 0 8.33333333333e-05 0 8.33343333333e-05 1 9.375e-05 1 9.3751e-05 0 0.000109375 0 0.000109376 1 0.000125 1 0.000125001 0 0.000140625 0 0.000140626 1 0.00015625 1 0.000156251 0 0.000182291666667 0 0.000182292666667 1 0.00021875 1 0.000218751 0 0.00028125 0 0.000281251 1 0.000317708333333 1 0.000317709333333 0 0.00034375 0 0.000343751 1 0.000359375 1 0.000359376 0 0.000375 0 0.000375001 1 0.000390625 1 0.000390626 0 0.00040625 0 0.000406251 1 0.000416666666667 1 0.000416667666667 0 0.000432291666667 0 0.000432292666667 1 0.000442708333333 1 0.000442709333333 0 0.000453125 0 0.000453126 1 0.00046875 1 0.000468751 0 0.000479166666667 0 0.000479167666667 1 0.000489583333333 1 0.000489584333333 0 0.0005 0 0.000500001 1 0.000510416666667 1 0.000510417666667 0 0.000520833333333 0 0.000520834333333 1 0.00053125 1 0.000531251 0 0.000546875 0 0.000546876 1 0.000557291666667 1 0.000557292666667 0 0.000567708333333 0 0.000567709333333 1 0.000583333333333 1 0.000583334333333 0 0.00059375 0 0.000593751 1 0.000609375 1 0.000609376 0 0.000625 0 0.000625001 1 0.000640625 1 0.000640626 0 0.00065625 0 0.000656251 1 0.000682291666667 1 0.000682292666667 0 0.00071875 0 0.000718751 1 0.00078125 1 0.000781251 0 0.000817708333333 0 0.000817709333333 1 0.00084375 1 0.000843751 0 0.000859375 0 0.000859376 1 0.000875 1 0.000875001 0 0.000890625 0 0.000890626 1 0.00090625 1 0.000906251 0 0.000916666666667 0 0.000916667666667 1 0.000932291666667 1 0.000932292666667 0 0.000942708333333 0 0.000942709333333 1 0.000953125 1 0.000953126 0 0.00096875 0 0.000968751 1 0.000979166666667 1 0.000979167666667 0 0.000989583333333 0 0.000989584333333 1)
Ba7 na7 0 V=1-v(ca7)
Sa7h da7 ref ca7 0 ideal
Sa7l da7 0 na7 0 ideal
Ra7v a7 da7 8391.53385982
Ra7h a7 a6 4195.76692991
Va8 ca8 0 PWL(0 0 2.08333333333e-05 0 2.08343333333e-05 1 4.6875e-05 1 4.6876e-05 0 6.77083333333e-05 0 6.77093333333e-05 1 9.375e-05 1 9.3751e-05 0 0.000125 0 0.000125001 1 0.00015625 1 0.000156251 0 0.00021875 0 0.000218751 1 0.00028125 1 0.000281251 0 0.00034375 0 0.000343751 1 0.000375 1 0.000375001 0 0.00040625 0 0.000406251 1 0.000432291666667 1 0.000432292666667 0 0.000453125 0 0.000453126 1 0.000479166666667 1 0.000479167666667 0 0.0005 0 0.000500001 1 0.000520833333333 1 0.000520834333333 0 0.000546875 0 0.000546876 1 0.000567708333333 1 0.000567709333333 0 0.00059375 0 0.000593751 1 0.000625 1 0.000625001 0 0.00065625 0 0.000656251 1 0.00071875 1 0.000718751 0 0.00078125 0 0.000781251 1 0.00084375 1 0.000843751 0 0.000875 0 0.000875001 1 0.00090625 1 0.000906251 0 0.000932291666667 0 0.000932292666667 1 0.000953125 1 0.000953126 0 0.000979166666667 0 0.000979167666667 1)
Ba8 na8 0 V=1-v(ca8)
Sa8h da8 ref ca8 0 ideal
Sa8l da8 0 na8 0 ideal
Ra8v a8 da8 8391.53385982
Ra8h a8 a7 4195.76692991
Va9 ca9 0 PWL(0 0 4.6875e-05 0 4.6876e-05 1 9.375e-05 1 9.3751e-05 0 0.00015625 0 0.000156251 1 0.00034375 1 0.000343751 0 0.00040625 0 0.000406251 1 0.000453125 1 0.000453126 0 0.0005 0 0.000500001 1 0.000546875 1 0.000546876 0 0.00059375 0 0.000593751 1 0.00065625 1 0.000656251 0 0.00084375 0 0.000843751 1 0.00090625 1 0.000906251 0 0.000953125 0 0.000953126 1)
Ba9 na9 0 V=1-v(ca9)
Sa9h da9 ref ca9 0 ideal
Sa9l da9 0 na9 0 ideal
Ra9v a9 da9 8391.53385982
Ra9h a9 a8 4195.76692991
Va10 ca10 0 PWL(0 0 9.375e-05 0 9.3751e-05 1 0.00040625 1 0.000406251 0 0.0005 0 0.000500001 1 0.00059375 1 0.000593751 0 0.00090625 0 0.000906251 1)
Ba10 na10 0 V=1-v(ca10)
Sa10h da10 ref ca10 0 ideal
Sa10l da10 0 na10 0 ideal
Ra10v a10 da10 8391.53385982
Ra10h a10 a9 4195.76692991
Va11 ca11 0 PWL(0 1 0.0005 1 0.000500001 0)
Ba11 na11 0 V=1-v(ca11)
Sa11h da11 ref ca11 0 ideal
Sa11l da11 0 na11 0 ideal
Ra11v a11 da11 8391.53385982
Ra11h a11 a10 4195.76692991
Raterm a0 0 8391.53385982
Vb0 cb0 0 PWL(0 0 2.08333333333e-05 0 2.08343333333e-05 1 3.64583333333e-05 1 3.64593333333e-05 0 4.6875e-05 0 4.6876e-05 1 5.20833333333e-05 1 5.20843333333e-05 0 6.25e-05 0 6.2501e-05 1 6.77083333333e-05 1 6.77093333333e-05 0 7.8125e-05 0 7.8126e-05 1 8.85416666667e-05 1 8.85426666667e-05 0 9.375e-05 0 9.3751e-05 1 9.89583333333e-05 1 9.89593333333e-05 0 0.000114583333333 0 0.000114584333333 1 0.000130208333333 1 0.000130209333333 0 0.000151041666667 0 0.000151042666667 1 0.000161458333333 1 0.000161459333333 0 0.000171875 0 0.000171876 1 0.000182291666667 1 0.000182292666667 0 0.0001875 0 0.000187501 1 0.000192708333333 1 0.000192709333333 0 0.000197916666667 0 0.000197917666667 1 0.000208333333333 1 0.000208334333333 0 0.00021875 0 0.000218751 1 0.00028125 1 0.000281251 0 0.000291666666667 0 0.000291667666667 1 0.000302083333333 1 0.000302084333333 0 0.000307291666667 0 0.000307292666667 1 0.0003125 1 0.000312501 0 0.000317708333333 0 0.000317709333333 1 0.000328125 1 0.000328126 0 0.000338541666667 0 0.000338542666667 1 0.000348958333333 1 0.000348959333333 0 0.000369791666667 0 0.000369792666667 1 0.000385416666667 1 0.000385417666667 0 0.000401041666667 0 0.000401042666667 1 0.00040625 1 0.000406251 0 0.000411458333333 0 0.000411459333333 1 0.000421875 1 0.000421876 0 0.000432291666667 0 0.000432292666667 1 0.0004375 1 0.000437501 0 0.000447916666667 0 0.000447917666667 1 0.000453125 1 0.000453126 0 0.000463541666667 0 0.000463542666667 1 0.000479166666667 1 0.000479167666667 0 0.0005 0 0.000500001 1 0.000520833333333 1 0.000520834333333 0 0.000536458333333 0 0.000536459333333 1 0.000546875 1 0.000546876 0 0.000552083333333 0 0.000552084333333 1 0.0005625 1 0.000562501 0 0.000567708333333 0 0.000567709333333 1 0.000578125 1 0.000578126 0 0.000588541666667 0 0.000588542666667 1 0.00059375 1 0.000593751 0 0.000598958333333 0 0.000598959333333 1 0.000614583333333 1 0.000614584333333 0 0.000630208333333 0 0.000630209333333 1 0.000651041666667 1 0.000651042666667 0 0.000661458333333 0 0.000661459333333 1 0.000671875 1 0.000671876 0 0.000682291666667 0 0.000682292666667 1 0.0006875 1 0.000687501 0 0.000692708333333 0 0.000692709333333 1 0.000697916666667 1 0.000697917666667 0 0.000708333333333 0 0.000708334333333 1 0.00071875 1 0.000718751 0 0.00078125 0 0.000781251 1 0.000791666666667 1 0.000791667666667 0 0.000802083333333 0 0.000802084333333 1 0.000807291666667 1 0.000807292666667 0 0.0008125 0 0.000812501 1 0.000817708333333 1 0.000817709333333 0 0.000828125 0 0.000828126 1 0.000838541666667 1 0.000838542666667 0 0.000848958333333 0 0.000848959333333 1 0.000869791666667 1 0.000869792666667 0 0.000885416666667 0 0.000885417666667 1 0.000901041666667 1 0.000901042666667 0 0.00090625 0 0.000906251 1 0.000911458333333 1 0.000911459333333 0 0.000921875 0 0.000921876 1 0.000932291666667 1 0.000932292666667 0 0.0009375 0 0.000937501 1 0.000947916666667 1 0.000947917666667 0 0.000953125 0 0.000953126 1 0.000963541666667 1 0.000963542666667 0 0.000979166666667 0 0.000979167666667 1)
Bb0 nb0 0 V=1-v(cb0)
Sb0h db0 ref cb0 0 ideal
Sb0l db0 0 nb0 0 ideal
Rb0v b0 db0 8391.53385982
Vb1 cb1 0 PWL(0 1 3.125e-05 1 3.1251e-05 0 3.64583333333e-05 0 3.64593333333e-05 1 4.16666666667e-05 1 4.16676666667e-05 0 4.6875e-05 0 4.6876e-05 1 6.77083333333e-05 1 6.77093333333e-05 0 7.29166666667e-05 0 7.29176666667e-05 1 7.8125e-05 1 7.8126e-05 0 8.85416666667e-05 0 8.85426666667e-05 1 9.375e-05 1 9.3751e-05 0 0.000109375 0 0.000109376 1 0.000114583333333 1 0.000114584333333 0 0.000125 0 0.000125001 1 0.000140625 1 0.000140626 0 0.00015625 0 0.000156251 1 0.000161458333333 1 0.000161459333333 0 0.000166666666667 0 0.000166667666667 1 0.000171875 1 0.000171876 0 0.000177083333333 0 0.000177084333333 1 0.000203125 1 0.000203126 0 0.000208333333333 0 0.000208334333333 1 0.000213541666667 1 0.000213542666667 0 0.000223958333333 0 0.000223959333333 1 0.000234375 1 0.000234376 0 0.000244791666667 0 0.000244792666667 1 0.000255208333333 1 0.000255209333333 0 0.000265625 0 0.000265626 1 0.000276041666667 1 0.000276042666667 0 0.000286458333333 0 0.000286459333333 1 0.000291666666667 1 0.000291667666667 0 0.000296875 0 0.000296876 1 0.000322916666667 1 0.000322917666667 0 0.000328125 0 0.000328126 1 0.000333333333333 1 0.000333334333333 0 0.000338541666667 0 0.000338542666667 1 0.00034375 1 0.000343751 0 0.000359375 0 0.000359376 1 0.000375 1 0.000375001 0 0.000385416666667 0 0.000385417666667 1 0.000390625 1 0.000390626 0 0.00040625 0 0.000406251 1 0.000411458333333 1 0.000411459333333 0 0.000421875 0 0.000421876 1 0.000427083333333 1 0.000427084333333 0 0.000432291666667 0 0.000432292666667 1 0.000453125 1 0.000453126 0 0.000458333333333 0 0.000458334333333 1 0.000463541666667 1 0.000463542666667 0 0.00046875 0 0.000468751 1 0.0005 1 0.000500001 0 0.00053125 0 0.000531251 1 0.000536458333333 1 0.000536459333333 0 0.000541666666667 0 0.000541667666667 1 0.000546875 1 0.000546876 0 0.000567708333333 0 0.000567709333333 1 0.000572916666667 1 0.000572917666667 0 0.000578125 0 0.000578126 1 0.000588541666667 1 0.000588542666667 0 0.00059375 0 0.000593751 1 0.000609375 1 0.000609376 0 0.000614583333333 0 0.000614584333333 1 0.000625 1 0.000625001 0 0.000640625 0 0.000640626 1 0.00065625 1 0.000656251 0 0.000661458333333 0 0.000661459333333 1 0.000666666666667 1 0.000666667666667 0 0.000671875 0 0.000671876 1 0.000677083333333 1 0.000677084333333 0 0.000703125 0 0.000703126 1 0.000708333333333 1 0.000708334333333 0 0.000713541666667 0 0.000713542666667 1 0.000723958333333 1 0.000723959333333 0 0.000734375 0 0.000734376 1 0.000744791666667 1 0.000744792666667 0 0.000755208333333 0 0.000755209333333 1 0.000765625 1 0.000765626 0 0.000776041666667 0 0.000776042666667 1 0.000786458333333 1 0.000786459333333 0 0.000791666666667 0 0.000791667666667 1 0.000796875 1 0.000796876 0 0.000822916666667 0 0.000822917666667 1 0.000828125 1 0.000828126 0 0.000833333333333 0 0.000833334333333 1 0.000838541666667 1 0.000838542666667 0 0.00084375 0 0.000843751 1 0.000859375 1 0.000859376 0 0.000875 0 0.000875001 1 0.000885416666667 1 0.000885417666667 0 0.000890625 0 0.000890626 1 0.00090625 1 0.000906251 0 0.000911458333333 0 0.000911459333333 1 0.000921875 1 0.000921876 0 0.000927083333333 0 0.000927084333333 1 0.000932291666667 1 0.000932292666667 0 0.000953125 0 0.000953126 1 0.000958333333333 1 0.000958334333333 0 0.000963541666667 0 0.000963542666667 1 0.00096875 1 0.000968751 0)
Bb1 nb1 0 V=1-v(cb1)
Sb1h db1 ref cb1 0 ideal
Sb1l db1 0 nb1 0 ideal
Rb1v b1 db1 8391.53385982
Rb1h b1 b0 4195.76692991
Vb2 cb2 0 PWL(0 0 5.20833333333e-06 0 5.20933333333e-06 1 1.04166666667e-05 1 1.04176666667e-05 0 1.5625e-05 0 1.5626e-05 1 2.08333333333e-05 1 2.08343333333e-05 0 2.60416666667e-05 0 2.60426666667e-05 1 3.64583333333e-05 1 3.64593333333e-05 0 4.6875e-05 0 4.6876e-05 1 6.77083333333e-05 1 6.77093333333e-05 0 7.8125e-05 0 7.8126e-05 1 8.33333333333e-05 1 8.33343333333e-05 0 8.85416666667e-05 0 8.85426666667e-05 1 0.000114583333333 1 0.000114584333333 0 0.000119791666667 0 0.000119792666667 1 0.000125 1 0.000125001 0 0.000140625 0 0.000140626 1 0.000145833333333 1 0.000145834333333 0 0.000151041666667 0 0.000151042666667 1 0.00015625 1 0.000156251 0 0.000161458333333 0 0.000161459333333 1 0.000171875 1 0.000171876 0 0.000177083333333 0 0.000177084333333 1 0.000192708333333 1 0.000192709333333 0 0.000197916666667 0 0.000197917666667 1 0.000213541666667 1 0.000213542666667 0 0.00021875 0 0.000218751 1 0.000223958333333 1 0.000223959333333 0 0.000234375 0 0.000234376 1 0.000239583333333 1 0.000239584333333 0 0.000244791666667 0 0.000244792666667 1 0.000255208333333 1 0.000255209333333 0 0.000260416666667 0 0.000260417666667 1 0.000265625 1 0.000265626 0 0.000276041666667 0 0.000276042666667 1 0.00028125 1 0.000281251 0 0.000286458333333 0 0.000286459333333 1 0.000302083333333 1 0.000302084333333 0 0.000307291666667 0 0.000307292666667 1 0.000322916666667 1 0.000322917666667 0 0.000328125 0 0.000328126 1 0.000338541666667 1 0.000338542666667 0 0.00034375 0 0.000343751 1 0.000348958333333 1 0.000348959333333 0 0.000354166666667 0 0.000354167666667 1 0.000359375 1 0.000359376 0 0.000375 0 0.000375001 1 0.000380208333333 1 0.000380209333333 0 0.000385416666667 0 0.000385417666667 1 0.000411458333333 1 0.000411459333333 0 0.000416666666667 0 0.000416667666667 1 0.000421875 1 0.000421876 0 0.000432291666667 0 0.000432292666667 1 0.000453125 1 0.000453126 0 0.000463541666667 0 0.000463542666667 1 0.000473958333333 1 0.000473959333333 0 0.000479166666667 0 0.000479167666667 1 0.000484375 1 0.000484376 0 0.000489583333333 0 0.000489584333333 1 0.000494791666667 1 0.000494792666667 0 0.0005 0 0.000500001 1 0.000505208333333 1 0.000505209333333 0 0.000510416666667 0 0.000510417666667 1 0.000515625 1 0.000515626 0 0.000520833333333 0 0.000520834333333 1 0.000526041666667 1 0.000526042666667 0 0.000536458333333 0 0.000536459333333 1 0.000546875 1 0.000546876 0 0.000567708333333 0 0.000567709333333 1 0.000578125 1 0.000578126 0 0.000583333333333 0 0.000583334333333 1 0.000588541666667 1 0.000588542666667 0 0.000614583333333 0 0.000614584333333 1 0.000619791666667 1 0.000619792666667 0 0.000625 0 0.000625001 1 0.000640625 1 0.000640626 0 0.000645833333333 0 0.000645834333333 1 0.000651041666667 1 0.000651042666667 0 0.00065625 0 0.000656251 1 0.000661458333333 1 0.000661459333333 0 0.000671875 0 0.000671876 1 0.000677083333333 1 0.000677084333333 0 0.000692708333333 0 0.000692709333333 1 0.000697916666667 1 0.000697917666667 0 0.000713541666667 0 0.000713542666667 1 0.00071875 1 0.000718751 0 0.000723958333333 0 0.000723959333333 1 0.000734375 1 0.000734376 0 0.000739583333333 0 0.000739584333333 1 0.000744791666667 1 0.000744792666667 0 0.000755208333333 0 0.000755209333333 1 0.000760416666667 1 0.000760417666667 0 0.000765625 0 0.000765626 1 0.000776041666667 1 0.000776042666667 0 0.00078125 0 0.000781251 1 0.000786458333333 1 0.000786459333333 0 0.000802083333333 0 0.000802084333333 1 0.000807291666667 1 0.000807292666667 0 0.000822916666667 0 0.000822917666667 1 0.000828125 1 0.000828126 0 0.000838541666667 0 0.000838542666667 1 0.00084375 1 0.000843751 0 0.000848958333333 0 0.000848959333333 1 0.000854166666667 1 0.000854167666667 0 0.000859375 0 0.000859376 1 0.000875 1 0.000875001 0 0.000880208333333 0 0.000880209333333 1 0.000885416666667 1 0.000885417666667 0 0.000911458333333 0 0.000911459333333 1 0.000916666666667 1 0.000916667666667 0 0.000921875 0 0.000921876 1 0.000932291666667 1 0.000932292666667 0 0.000953125 0 0.000953126 1 0.000963541666667 1 0.000963542666667 0 0.000973958333333 0 0.000973959333333 1 0.000979166666667 1 0.000979167666667 0 0.000984375 0 0.000984376 1 0.000989583333333 1 0.000989584333333 0 0.000994791666667 0 0.000994792666667 1)
Bb2 nb2 0 V=1-v(cb2)
Sb2h db2 ref cb2 0 ideal
Sb2l db2 0 nb2 0 ideal
Rb2v b2 db2 8391.53385982
Rb2h b2 b1 4195.76692991
Vb3 cb3 0 PWL(0 0 1.04166666667e-05 0 1.04176666667e-05 1 2.08333333333e-05 1 2.08343333333e-05 0 3.125e-05 0 3.1251e-05 1 3.64583333333e-05 1 3.64593333333e-05 0 4.16666666667e-05 0 4.16676666667e-05 1 5.20833333333e-05 1 5.20843333333e-05 0 5.72916666667e-05 0 5.72926666667e-05 1 6.25e-05 1 6.2501e-05 0 7.29166666667e-05 0 7.29176666667e-05 1 7.8125e-05 1 7.8126e-05 0 8.85416666667e-05 0 8.85426666667e-05 1 0.000114583333333 1 0.000114584333333 0 0.000125 0 0.000125001 1 0.000130208333333 1 0.000130209333333 0 0.000135416666667 0 0.000135417666667 1 0.000140625 1 0.000140626 0 0.000151041666667 0 0.000151042666667 1 0.000171875 1 0.000171876 0 0.000182291666667 0 0.000182292666667 1 0.0001875 1 0.000187501 0 0.000197916666667 0 0.000197917666667 1 0.000213541666667 1 0.000213542666667 0 0.000223958333333 0 0.000223959333333 1 0.000229166666667 1 0.000229167666667 0 0.000234375 0 0.000234376 1 0.000244791666667 1 0.000244792666667 0 0.000255208333333 0 0.000255209333333 1 0.000265625 1 0.000265626 0 0.000270833333333 0 0.000270834333333 1 0.000276041666667 1 0.000276042666667 0 0.000286458333333 0 0.000286459333333 1 0.000302083333333 1 0.000302084333333 0 0.0003125 0 0.000312501 1 0.000317708333333 1 0.000317709333333 0 0.000328125 0 0.000328126 1 0.000348958333333 1 0.000348959333333 0 0.000359375 0 0.000359376 1 0.000364583333333 1 0.000364584333333 0 0.000369791666667 0 0.000369792666667 1 0.000375 1 0.000375001 0 0.000385416666667 0 0.000385417666667 1 0.000411458333333 1 0.000411459333333 0 0.000421875 0 0.000421876 1 0.000427083333333 1 0.000427084333333 0 0.0004375 0 0.000437501 1 0.000442708333333 1 0.000442709333333 0 0.000447916666667 0 0.000447917666667 1 0.000458333333333 1 0.000458334333333 0 0.000463541666667 0 0.000463542666667 1 0.00046875 1 0.000468751 0 0.000479166666667 0 0.000479167666667 1 0.000489583333333 1 0.000489584333333 0 0.0005 0 0.000500001 1 0.000510416666667 1 0.000510417666667 0 0.000520833333333 0 0.000520834333333 1 0.00053125 1 0.000531251 0 0.000536458333333 0 0.000536459333333 1 0.000541666666667 1 0.000541667666667 0 0.000552083333333 0 0.000552084333333 1 0.000557291666667 1 0.000557292666667 0 0.0005625 0 0.000562501 1 0.000572916666667 1 0.000572917666667 0 0.000578125 0 0.000578126 1 0.000588541666667 1 0.000588542666667 0 0.000614583333333 0 0.000614584333333 1 0.000625 1 0.000625001 0 0.000630208333333 0 0.000630209333333 1 0.000635416666667 1 0.000635417666667 0 0.000640625 0 0.000640626 1 0.000651041666667 1 0.000651042666667 0 0.000671875 0 0.000671876 1 0.000682291666667 1 0.000682292666667 0 0.0006875 0 0.000687501 1 0.000697916666667 1 0.000697917666667 0 0.000713541666667 0 0.000713542666667 1 0.000723958333333 1 0.000723959333333 0 0.000729166666667 0 0.000729167666667 1 0.000734375 1 0.000734376 0 0.000744791666667 0 0.000744792666667 1 0.000755208333333 1 0.000755209333333 0 0.000765625 0 0.000765626 1 0.000770833333333 1 0.000770834333333 0 0.000776041666667 0 0.000776042666667 1 0.000786458333333 1 0.000786459333333 0 0.000802083333333 0 0.000802084333333 1 0.0008125 1 0.000812501 0 0.000817708333333 0 0.000817709333333 1 0.000828125 1 0.000828126 0 0.000848958333333 0 0.000848959333333 1 0.000859375 1 0.000859376 0 0.000864583333333 0 0.000864584333333 1 0.000869791666667 1 0.000869792666667 0 0.000875 0 0.000875001 1 0.000885416666667 1 0.000885417666667 0 0.000911458333333 0 0.000911459333333 1 0.000921875 1 0.000921876 0 0.000927083333333 0 0.000927084333333 1 0.0009375 1 0.000937501 0 0.000942708333333 0 0.000942709333333 1 0.000947916666667 1 0.000947917666667 0 0.000958333333333 0 0.000958334333333 1 0.000963541666667 1 0.000963542666667 0 0.00096875 0 0.000968751 1 0.000979166666667 1 0.000979167666667 0 0.000989583333333 0 0.000989584333333 1)
Bb3 nb3 0 V=1-v(cb3)
Sb3h db3 ref cb3 0 ideal
Sb3l db3 0 nb3 0 ideal
Rb3v b3 db3 8391.53385982
Rb3h b3 b2 4195.76692991
Vb4 cb4 0 PWL(0 0 2.08333333333e-05 0 2.08343333333e-05 1 3.64583333333e-05 1 3.64593333333e-05 0 5.20833333333e-05 0 5.20843333333e-05 1 6.25e-05 1 6.2501e-05 0 6.77083333333e-05 0 6.77093333333e-05 1 7.8125e-05 1 7.8126e-05 0 8.33333333333e-05 0 8.33343333333e-05 1 9.375e-05 1 9.3751e-05 0 9.89583333333e-05 0 9.89593333333e-05 1 0.000104166666667 1 0.000104167666667 0 0.000109375 0 0.000109376 1 0.000119791666667 1 0.000119792666667 0 0.000125 0 0.000125001 1 0.000135416666667 1 0.000135417666667 0 0.000151041666667 0 0.000151042666667 1 0.000171875 1 0.000171876 0 0.0001875 0 0.000187501 1 0.000192708333333 1 0.000192709333333 0 0.000203125 0 0.000203126 1 0.000208333333333 1 0.000208334333333 0 0.00021875 0 0.000218751 1 0.000223958333333 1 0.000223959333333 0 0.000234375 0 0.000234376 1 0.000265625 1 0.000265626 0 0.000276041666667 0 0.000276042666667 1 0.00028125 1 0.000281251 0 0.000291666666667 0 0.000291667666667 1 0.000296875 1 0.000296876 0 0.000307291666667 0 0.000307292666667 1 0.0003125 1 0.000312501 0 0.000328125 0 0.000328126 1 0.000348958333333 1 0.000348959333333 0 0.000364583333333 0 0.000364584333333 1 0.000375 1 0.000375001 0 0.000380208333333 0 0.000380209333333 1 0.000390625 1 0.000390626 0 0.000395833333333 0 0.000395834333333 1 0.000401041666667 1 0.000401042666667 0 0.00040625 0 0.000406251 1 0.000416666666667 1 0.000416667666667 0 0.000421875 0 0.000421876 1 0.000432291666667 1 0.000432292666667 0 0.0004375 0 0.000437501 1 0.000447916666667 1 0.000447917666667 0 0.000463541666667 0 0.000463542666667 1 0.000479166666667 1 0.000479167666667 0 0.0005 0 0.000500001 1 0.000520833333333 1 0.000520834333333 0 0.000536458333333 0 0.000536459333333 1 0.000552083333333 1 0.000552084333333 0 0.0005625 0 0.000562501 1 0.000567708333333 1 0.000567709333333 0 0.000578125 0 0.000578126 1 0.000583333333333 1 0.000583334333333 0 0.00059375 0 0.000593751 1 0.000598958333333 1 0.000598959333333 0 0.000604166666667 0 0.000604167666667 1 0.000609375 1 0.000609376 0 0.000619791666667 0 0.000619792666667 1 0.000625 1 0.000625001 0 0.000635416666667 0 0.000635417666667 1 0.000651041666667 1 0.000651042666667 0 0.000671875 0 0.000671876 1 0.0006875 1 0.000687501 0 0.000692708333333 0 0.000692709333333 1 0.000703125 1 0.000703126 0 0.000708333333333 0 0.000708334333333 1 0.00071875 1 0.000718751 0 0.000723958333333 0 0.000723959333333 1 0.000734375 1 0.000734376 0 0.000765625 0 0.000765626 1 0.000776041666667 1 0.000776042666667 0 0.00078125 0 0.000781251 1 0.000791666666667 1 0.000791667666667 0 0.000796875 0 0.000796876 1 0.000807291666667 1 0.000807292666667 0 0.0008125 0 0.000812501 1 0.000828125 1 0.000828126 0 0.000848958333333 0 0.000848959333333 1 0.000864583333333 1 0.000864584333333 0 0.000875 0 0.000875001 1 0.000880208333333 1 0.000880209333333 0 0.000890625 0 0.000890626 1 0.000895833333333 1 0.000895834333333 0 0.000901041666667 0 0.000901042666667 1 0.00090625 1 0.000906251 0 0.000916666666667 0 0.000916667666667 1 0.000921875 1 0.000921876 0 0.000932291666667 0 0.000932292666667 1 0.0009375 1 0.000937501 0 0.000947916666667 0 0.000947917666667 1 0.000963541666667 1 0.000963542666667 0 0.000979166666667 0 0.000979167666667 1)
Bb4 nb4 0 V=1-v(cb4)
Sb4h db4 ref cb4 0 ideal
Sb4l db4 0 nb4 0 ideal
Rb4v b4 db4 8391.53385982
Rb4h b4 b3 4195.76692991
Vb5 cb5 0 PWL(0 1 3.64583333333e-05 1 3.64593333333e-05 0 6.25e-05 0 6.2501e-05 1 7.8125e-05 1 7.8126e-05 0 9.375e-05 0 9.3751e-05 1 0.000104166666667 1 0.000104167666667 0 0.000114583333333 0 0.000114584333333 1 0.000119791666667 1 0.000119792666667 0 0.000130208333333 0 0.000130209333333 1 0.000135416666667 1 0.000135417666667 0 0.000140625 0 0.000140626 1 0.000145833333333 1 0.000145834333333 0 0.00015625 0 0.000156251 1 0.000161458333333 1 0.000161459333333 0 0.000166666666667 0 0.000166667666667 1 0.000177083333333 1 0.000177084333333 0 0.000182291666667 0 0.000182292666667 1 0.0001875 1 0.000187501 0 0.000197916666667 0 0.000197917666667 1 0.000203125 1 0.000203126 0 0.00021875 0 0.000218751 1 0.000234375 1 0.000234376 0 0.000265625 0 0.000265626 1 0.00028125 1 0.000281251 0 0.000296875 0 0.000296876 1 0.000302083333333 1 0.000302084333333 0 0.0003125 0 0.000312501 1 0.000317708333333 1 0.000317709333333 0 0.000322916666667 0 0.000322917666667 1 0.000333333333333 1 0.000333334333333 0 0.000338541666667 0 0.000338542666667 1 0.00034375 1 0.000343751 0 0.000354166666667 0 0.000354167666667 1 0.000359375 1 0.000359376 0 0.000364583333333 0 0.000364584333333 1 0.000369791666667 1 0.000369792666667 0 0.000380208333333 0 0.000380209333333 1 0.000385416666667 1 0.000385417666667 0 0.000395833333333 0 0.000395834333333 1 0.00040625 1 0.000406251 0 0.000421875 0 0.000421876 1 0.0004375 1 0.000437501 0 0.000463541666667 0 0.000463542666667 1 0.0005 1 0.000500001 0 0.000536458333333 0 0.000536459333333 1 0.0005625 1 0.000562501 0 0.000578125 0 0.000578126 1 0.00059375 1 0.000593751 0 0.000604166666667 0 0.000604167666667 1 0.000614583333333 1 0.000614584333333 0 0.000619791666667 0 0.000619792666667 1 0.000630208333333 1 0.000630209333333 0 0.000635416666667 0 0.000635417666667 1 0.000640625 1 0.000640626 0 0.000645833333333 0 0.000645834333333 1 0.00065625 1 0.000656251 0 0.000661458333333 0 0.000661459333333 1 0.000666666666667 1 0.000666667666667 0 0.000677083333333 0 0.000677084333333 1 0.000682291666667 1 0.000682292666667 0 0.0006875 0 0.000687501 1 0.000697916666667 1 0.000697917666667 0 0.000703125 0 0.000703126 1 0.00071875 1 0.000718751 0 0.000734375 0 0.000734376 1 0.000765625 1 0.000765626 0 0.00078125 0 0.000781251 1 0.000796875 1 0.000796876 0 0.000802083333333 0 0.000802084333333 1 0.0008125 1 0.000812501 0 0.000817708333333 0 0.000817709333333 1 0.000822916666667 1 0.000822917666667 0 0.000833333333333 0 0.000833334333333 1 0.000838541666667 1 0.000838542666667 0 0.00084375 0 0.000843751 1 0.000854166666667 1 0.000854167666667 0 0.000859375 0 0.000859376 1 0.000864583333333 1 0.000864584333333 0 0.000869791666667 0 0.000869792666667 1 0.000880208333333 1 0.000880209333333 0 0.000885416666667 0 0.000885417666667 1 0.000895833333333 1 0.000895834333333 0 0.00090625 0 0.000906251 1 0.000921875 1 0.000921876 0 0.0009375 0 0.000937501 1 0.000963541666667 1 0.000963542666667 0)
Bb5 nb5 0 V=1-v(cb5)
Sb5h db5 ref cb5 0 ideal
Sb5l db5 0 nb5 0 ideal
Rb5v b5 db5 8391.53385982
Rb5h b5 b4 4195.76692991
Vb6 cb6 0 PWL(0 1 5.20833333333e-06 1 5.20933333333e-06 0 1.04166666667e-05 0 1.04176666667e-05 1 1.5625e-05 1 1.5626e-05 0 2.08333333333e-05 0 2.08343333333e-05 1 2.60416666667e-05 1 2.60426666667e-05 0 3.125e-05 0 3.1251e-05 1 4.16666666667e-05 1 4.16676666667e-05 0 4.6875e-05 0 4.6876e-05 1 5.20833333333e-05 1 5.20843333333e-05 0 5.72916666667e-05 0 5.72926666667e-05 1 6.25e-05 1 6.2501e-05 0 6.77083333333e-05 0 6.77093333333e-05 1 7.29166666667e-05 1 7.29176666667e-05 0 8.33333333333e-05 0 8.33343333333e-05 1 8.85416666667e-05 1 8.85426666667e-05 0 9.375e-05 0 9.3751e-05 1 9.89583333333e-05 1 9.89593333333e-05 0 0.000109375 0 0.000109376 1 0.000114583333333 1 0.000114584333333 0 0.000125 0 0.000125001 1 0.000130208333333 1 0.000130209333333 0 0.000140625 0 0.000140626 1 0.000151041666667 1 0.000151042666667 0 0.00015625 0 0.000156251 1 0.000166666666667 1 0.000166667666667 0 0.000182291666667 0 0.000182292666667 1 0.000197916666667 1 0.000197917666667 0 0.00021875 0 0.000218751 1 0.00028125 1 0.000281251 0 0.000302083333333 0 0.000302084333333 1 0.000317708333333 1 0.000317709333333 0 0.000333333333333 0 0.000333334333333 1 0.00034375 1 0.000343751 0 0.000348958333333 0 0.000348959333333 1 0.000359375 1 0.000359376 0 0.000369791666667 0 0.000369792666667 1 0.000375 1 0.000375001 0 0.000385416666667 0 0.000385417666667 1 0.000390625 1 0.000390626 0 0.000401041666667 0 0.000401042666667 1 0.00040625 1 0.000406251 0 0.000411458333333 0 0.000411459333333 1 0.000416666666667 1 0.000416667666667 0 0.000427083333333 0 0.000427084333333 1 0.000432291666667 1 0.000432292666667 0 0.0004375 0 0.000437501 1 0.000442708333333 1 0.000442709333333 0 0.000447916666667 0 0.000447917666667 1 0.000453125 1 0.000453126 0 0.000458333333333 0 0.000458334333333 1 0.00046875 1 0.000468751 0 0.000473958333333 0 0.000473959333333 1 0.000479166666667 1 0.000479167666667 0 0.000484375 0 0.000484376 1 0.000489583333333 1 0.000489584333333 0 0.000494791666667 0 0.000494792666667 1 0.0005 1 0.000500001 0 0.000505208333333 0 0.000505209333333 1 0.000510416666667 1 0.000510417666667 0 0.000515625 0 0.000515626 1 0.000520833333333 1 0.000520834333333 0 0.000526041666667 0 0.000526042666667 1 0.00053125 1 0.000531251 0 0.000541666666667 0 0.000541667666667 1 0.000546875 1 0.000546876 0 0.000552083333333 0 0.000552084333333 1 0.000557291666667 1 0.000557292666667 0 0.0005625 0 0.000562501 1 0.000567708333333 1 0.000567709333333 0 0.000572916666667 0 0.000572917666667 1 0.000583333333333 1 0.000583334333333 0 0.000588541666667 0 0.000588542666667 1 0.00059375 1 0.000593751 0 0.000598958333333 0 0.000598959333333 1 0.000609375 1 0.000609376 0 0.000614583333333 0 0.000614584333333 1 0.000625 1 0.000625001 0 0.000630208333333 0 0.000630209333333 1 0.000640625 1 0.000640626 0 0.000651041666667 0 0.000651042666667 1 0.00065625 1 0.000656251 0 0.000666666666667 0 0.000666667666667 1 0.000682291666667 1 0.000682292666667 0 0.000697916666667 0 0.000697917666667 1 0.00071875 1 0.000718751 0 0.00078125 0 0.000781251 1 0.000802083333333 1 0.000802084333333 0 0.000817708333333 0 0.000817709333333 1 0.000833333333333 1 0.000833334333333 0 0.00084375 0 0.000843751 1 0.000848958333333 1 0.000848959333333 0 0.000859375 0 0.000859376 1 0.000869791666667 1 0.000869792666667 0 0.000875 0 0.000875001 1 0.000885416666667 1 0.000885417666667 0 0.000890625 0 0.000890626 1 0.000901041666667 1 0.000901042666667 0 0.00090625 0 0.000906251 1 0.000911458333333 1 0.000911459333333 0 0.000916666666667 0 0.000916667666667 1 0.000927083333333 1 0.000927084333333 0 0.000932291666667 0 0.000932292666667 1 0.0009375 1 0.000937501 0 0.000942708333333 0 0.000942709333333 1 0.000947916666667 1 0.000947917666667 0 0.000953125 0 0.000953126 1 0.000958333333333 1 0.000958334333333 0 0.00096875 0 0.000968751 1 0.000973958333333 1 0.000973959333333 0 0.000979166666667 0 0.000979167666667 1 0.000984375 1 0.000984376 0 0.000989583333333 0 0.000989584333333 1 0.000994791666667 1 0.000994792666667 0)
Bb6 nb6 0 V=1-v(cb6)
Sb6h db6 ref cb6 0 ideal
Sb6l db6 0 nb6 0 ideal
Rb6v b6 db6 8391.53385982
Rb6h b6 b5 4195.76692991
Vb7 cb7 0 PWL(0 1 1.04166666667e-05 1 1.04176666667e-05 0 2.08333333333e-05 0 2.08343333333e-05 1 3.125e-05 1 3.1251e-05 0 4.6875e-05 0 4.6876e-05 1 5.72916666667e-05 1 5.72926666667e-05 0 6.77083333333e-05 0 6.77093333333e-05 1 8.33333333333e-05 1 8.33343333333e-05 0 9.375e-05 0 9.3751e-05 1 0.000109375 1 0.000109376 0 0.000125 0 0.000125001 1 0.000140625 1 0.000140626 0 0.00015625 0 0.000156251 1 0.000182291666667 1 0.000182292666667 0 0.00021875 0 0.000218751 1 0.00028125 1 0.000281251 0 0.000317708333333 0 0.000317709333333 1 0.00034375 1 0.000343751 0 0.000359375 0 0.000359376 1 0.000375 1 0.000375001 0 0.000390625 0 0.000390626 1 0.00040625 1 0.000406251 0 0.000416666666667 0 0.000416667666667 1 0.000432291666667 1 0.000432292666667 0 0.000442708333333 0 0.000442709333333 1 0.000453125 1 0.000453126 0 0.00046875 0 0.000468751 1 0.000479166666667 1 0.000479167666667 0 0.000489583333333 0 0.000489584333333 1 0.0005 1 0.000500001 0 0.000510416666667 0 0.000510417666667 1 0.000520833333333 1 0.000520834333333 0 0.00053125 0 0.000531251 1 0.000546875 1 0.000546876 0 0.000557291666667 0 0.000557292666667 1 0.000567708333333 1 0.000567709333333 0 0.000583333333333 0 0.000583334333333 1 0.00059375 1 0.000593751 0 0.000609375 0 0.000609376 1 0.000625 1 0.000625001 0 0.000640625 0 0.000640626 1 0.00065625 1 0.000656251 0 0.000682291666667 0 0.000682292666667 1 0.00071875 1 0.000718751 0 0.00078125 0 0.000781251 1 0.000817708333333 1 0.000817709333333 0 0.00084375 0 0.000843751 1 0.000859375 1 0.000859376 0 0.000875 0 0.000875001 1 0.000890625 1 0.000890626 0 0.00090625 0 0.000906251 1 0.000916666666667 1 0.000916667666667 0 0.000932291666667 0 0.000932292666667 1 0.000942708333333 1 0.000942709333333 0 0.000953125 0 0.000953126 1 0.00096875 1 0.000968751 0 0.000979166666667 0 0.000979167666667 1 0.000989583333333 1 0.000989584333333 0)
Bb7 nb7 0 V=1-v(cb7)
Sb7h db7 ref cb7 0 ideal
Sb7l db7 0 nb7 0 ideal
Rb7v b7 db7 8391.53385982
Rb7h b7 b6 4195.76692991
Vb8 cb8 0 PWL(0 1 2.08333333333e-05 1 2.08343333333e-05 0 4.6875e-05 0 4.6876e-05 1 6.77083333333e-05 1 6.77093333333e-05 0 9.375e-05 0 9.3751e-05 1 0.000125 1 0.000125001 0 0.00015625 0 0.000156251 1 0.00021875 1 0.000218751 0 0.00028125 0 0.000281251 1 0.00034375 1 0.000343751 0 0.000375 0 0.000375001 1 0.00040625 1 0.000406251 0 0.000432291666667 0 0.000432292666667 1 0.000453125 1 0.000453126 0 0.000479166666667 0 0.000479167666667 1 0.0005 1 0.000500001 0 0.000520833333333 0 0.000520834333333 1 0.000546875 1 0.000546876 0 0.000567708333333 0 0.000567709333333 1 0.00059375 1 0.000593751 0 0.000625 0 0.000625001 1 0.00065625 1 0.000656251 0 0.00071875 0 0.000718751 1 0.00078125 1 0.000781251 0 0.00084375 0 0.000843751 1 0.000875 1 0.000875001 0 0.00090625 0 0.000906251 1 0.000932291666667 1 0.000932292666667 0 0.000953125 0 0.000953126 1 0.000979166666667 1 0.000979167666667 0)
Bb8 nb8 0 V=1-v(cb8)
Sb8h db8 ref cb8 0 ideal
Sb8l db8 0 nb8 0 ideal
Rb8v b8 db8 8391.53385982
Rb8h b8 b7 4195.76692991
Vb9 cb9 0 PWL(0 1 4.6875e-05 1 4.6876e-05 0 9.375e-05 0 9.3751e-05 1 0.00015625 1 0.000156251 0 0.00034375 0 0.000343751 1 0.00040625 1 0.000406251 0 0.000453125 0 0.000453126 1 0.0005 1 0.000500001 0 0.000546875 0 0.000546876 1 0.00059375 1 0.000593751 0 0.00065625 0 0.000656251 1 0.00084375 1 0.000843751 0 0.00090625 0 0.000906251 1 0.000953125 1 0.000953126 0)
Bb9 nb9 0 V=1-v(cb9)
Sb9h db9 ref cb9 0 ideal
Sb9l db9 0 nb9 0 ideal
Rb9v b9 db9 8391.53385982
Rb9h b9 b8 4195.76692991
Vb10 cb10 0 PWL(0 1 9.375e-05 1 9.3751e-05 0 0.00040625 0 0.000406251 1 0.0005 1 0.000500001 0 0.00059375 0 0.000593751 1 0.00090625 1 0.000906251 0)
Bb10 nb10 0 V=1-v(cb10)
Sb10h db10 ref cb10 0 ideal
Sb10l db10 0 nb10 0 ideal
Rb10v b10 db10 8391.53385982
Rb10h b10 b9 4195.76692991
Vb11 cb11 0 PWL(0 0 0.0005 0 0.000500001 1)
Bb11 nb11 0 V=1-v(cb11)
Sb11h db11 ref cb11 0 ideal
Sb11l db11 0 nb11 0 ideal
Rb11v b11 db11 8391.53385982
Rb11h b11 b10 4195.76692991
Rbterm b0 0 8391.53385982
Rload a11 b11 10000
.tran 100n 1m 0 100n
.end
