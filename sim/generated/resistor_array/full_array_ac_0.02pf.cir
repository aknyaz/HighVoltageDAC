169 kohm single-MPN candidate, 5 V simulation only
.options reltol=1e-8 abstol=1e-14
Vcode code 0 0
Vac0 ac0in 0 DC 0 AC 0.5
Rac0_0_0 ac0in nac0_0_0 169000.0
Cac0_0_0 nac0_0_0 0 0.02p
Rac0_0_1 nac0_0_0 nac0_0_1 169000.0
Cac0_0_1 nac0_0_1 0 0.02p
Rac0_0_2 nac0_0_1 nac0_0_2 169000.0
Cac0_0_2 nac0_0_2 0 0.02p
Rac0_0_3 nac0_0_2 nac0_0_3 169000.0
Cac0_0_3 nac0_0_3 0 0.02p
Rac0_0_4 nac0_0_3 nac0_0_4 169000.0
Cac0_0_4 nac0_0_4 0 0.02p
Rac0_0_5 nac0_0_4 a 169000.0
Rac0_1_0 ac0in nac0_1_0 169000.0
Cac0_1_0 nac0_1_0 0 0.02p
Rac0_1_1 nac0_1_0 nac0_1_1 169000.0
Cac0_1_1 nac0_1_1 0 0.02p
Rac0_1_2 nac0_1_1 nac0_1_2 169000.0
Cac0_1_2 nac0_1_2 0 0.02p
Rac0_1_3 nac0_1_2 nac0_1_3 169000.0
Cac0_1_3 nac0_1_3 0 0.02p
Rac0_1_4 nac0_1_3 nac0_1_4 169000.0
Cac0_1_4 nac0_1_4 0 0.02p
Rac0_1_5 nac0_1_4 a 169000.0
Rac0_2_0 ac0in nac0_2_0 169000.0
Cac0_2_0 nac0_2_0 0 0.02p
Rac0_2_1 nac0_2_0 nac0_2_1 169000.0
Cac0_2_1 nac0_2_1 0 0.02p
Rac0_2_2 nac0_2_1 nac0_2_2 169000.0
Cac0_2_2 nac0_2_2 0 0.02p
Rac0_2_3 nac0_2_2 nac0_2_3 169000.0
Cac0_2_3 nac0_2_3 0 0.02p
Rac0_2_4 nac0_2_3 nac0_2_4 169000.0
Cac0_2_4 nac0_2_4 0 0.02p
Rac0_2_5 nac0_2_4 a 169000.0
Rac0_3_0 ac0in nac0_3_0 169000.0
Cac0_3_0 nac0_3_0 0 0.02p
Rac0_3_1 nac0_3_0 nac0_3_1 169000.0
Cac0_3_1 nac0_3_1 0 0.02p
Rac0_3_2 nac0_3_1 nac0_3_2 169000.0
Cac0_3_2 nac0_3_2 0 0.02p
Rac0_3_3 nac0_3_2 nac0_3_3 169000.0
Cac0_3_3 nac0_3_3 0 0.02p
Rac0_3_4 nac0_3_3 nac0_3_4 169000.0
Cac0_3_4 nac0_3_4 0 0.02p
Rac0_3_5 nac0_3_4 a 169000.0
Rac0_4_0 ac0in nac0_4_0 169000.0
Cac0_4_0 nac0_4_0 0 0.02p
Rac0_4_1 nac0_4_0 nac0_4_1 169000.0
Cac0_4_1 nac0_4_1 0 0.02p
Rac0_4_2 nac0_4_1 nac0_4_2 169000.0
Cac0_4_2 nac0_4_2 0 0.02p
Rac0_4_3 nac0_4_2 nac0_4_3 169000.0
Cac0_4_3 nac0_4_3 0 0.02p
Rac0_4_4 nac0_4_3 nac0_4_4 169000.0
Cac0_4_4 nac0_4_4 0 0.02p
Rac0_4_5 nac0_4_4 a 169000.0
Rac0_5_0 ac0in nac0_5_0 169000.0
Cac0_5_0 nac0_5_0 0 0.02p
Rac0_5_1 nac0_5_0 nac0_5_1 169000.0
Cac0_5_1 nac0_5_1 0 0.02p
Rac0_5_2 nac0_5_1 nac0_5_2 169000.0
Cac0_5_2 nac0_5_2 0 0.02p
Rac0_5_3 nac0_5_2 nac0_5_3 169000.0
Cac0_5_3 nac0_5_3 0 0.02p
Rac0_5_4 nac0_5_3 nac0_5_4 169000.0
Cac0_5_4 nac0_5_4 0 0.02p
Rac0_5_5 nac0_5_4 a 169000.0
Rac0_6_0 ac0in nac0_6_0 169000.0
Cac0_6_0 nac0_6_0 0 0.02p
Rac0_6_1 nac0_6_0 nac0_6_1 169000.0
Cac0_6_1 nac0_6_1 0 0.02p
Rac0_6_2 nac0_6_1 nac0_6_2 169000.0
Cac0_6_2 nac0_6_2 0 0.02p
Rac0_6_3 nac0_6_2 nac0_6_3 169000.0
Cac0_6_3 nac0_6_3 0 0.02p
Rac0_6_4 nac0_6_3 nac0_6_4 169000.0
Cac0_6_4 nac0_6_4 0 0.02p
Rac0_6_5 nac0_6_4 a 169000.0
Rac0_7_0 ac0in nac0_7_0 169000.0
Cac0_7_0 nac0_7_0 0 0.02p
Rac0_7_1 nac0_7_0 nac0_7_1 169000.0
Cac0_7_1 nac0_7_1 0 0.02p
Rac0_7_2 nac0_7_1 nac0_7_2 169000.0
Cac0_7_2 nac0_7_2 0 0.02p
Rac0_7_3 nac0_7_2 nac0_7_3 169000.0
Cac0_7_3 nac0_7_3 0 0.02p
Rac0_7_4 nac0_7_3 nac0_7_4 169000.0
Cac0_7_4 nac0_7_4 0 0.02p
Rac0_7_5 nac0_7_4 a 169000.0
Rac0_8_0 ac0in nac0_8_0 169000.0
Cac0_8_0 nac0_8_0 0 0.02p
Rac0_8_1 nac0_8_0 nac0_8_1 169000.0
Cac0_8_1 nac0_8_1 0 0.02p
Rac0_8_2 nac0_8_1 nac0_8_2 169000.0
Cac0_8_2 nac0_8_2 0 0.02p
Rac0_8_3 nac0_8_2 nac0_8_3 169000.0
Cac0_8_3 nac0_8_3 0 0.02p
Rac0_8_4 nac0_8_3 nac0_8_4 169000.0
Cac0_8_4 nac0_8_4 0 0.02p
Rac0_8_5 nac0_8_4 a 169000.0
Rac0_9_0 ac0in nac0_9_0 169000.0
Cac0_9_0 nac0_9_0 0 0.02p
Rac0_9_1 nac0_9_0 nac0_9_1 169000.0
Cac0_9_1 nac0_9_1 0 0.02p
Rac0_9_2 nac0_9_1 nac0_9_2 169000.0
Cac0_9_2 nac0_9_2 0 0.02p
Rac0_9_3 nac0_9_2 nac0_9_3 169000.0
Cac0_9_3 nac0_9_3 0 0.02p
Rac0_9_4 nac0_9_3 nac0_9_4 169000.0
Cac0_9_4 nac0_9_4 0 0.02p
Rac0_9_5 nac0_9_4 a 169000.0
Rac0_10_0 ac0in nac0_10_0 169000.0
Cac0_10_0 nac0_10_0 0 0.02p
Rac0_10_1 nac0_10_0 nac0_10_1 169000.0
Cac0_10_1 nac0_10_1 0 0.02p
Rac0_10_2 nac0_10_1 nac0_10_2 169000.0
Cac0_10_2 nac0_10_2 0 0.02p
Rac0_10_3 nac0_10_2 nac0_10_3 169000.0
Cac0_10_3 nac0_10_3 0 0.02p
Rac0_10_4 nac0_10_3 nac0_10_4 169000.0
Cac0_10_4 nac0_10_4 0 0.02p
Rac0_10_5 nac0_10_4 a 169000.0
Rac0_11_0 ac0in nac0_11_0 169000.0
Cac0_11_0 nac0_11_0 0 0.02p
Rac0_11_1 nac0_11_0 nac0_11_1 169000.0
Cac0_11_1 nac0_11_1 0 0.02p
Rac0_11_2 nac0_11_1 nac0_11_2 169000.0
Cac0_11_2 nac0_11_2 0 0.02p
Rac0_11_3 nac0_11_2 nac0_11_3 169000.0
Cac0_11_3 nac0_11_3 0 0.02p
Rac0_11_4 nac0_11_3 nac0_11_4 169000.0
Cac0_11_4 nac0_11_4 0 0.02p
Rac0_11_5 nac0_11_4 a 169000.0
Rac0_12_0 ac0in nac0_12_0 169000.0
Cac0_12_0 nac0_12_0 0 0.02p
Rac0_12_1 nac0_12_0 nac0_12_1 169000.0
Cac0_12_1 nac0_12_1 0 0.02p
Rac0_12_2 nac0_12_1 nac0_12_2 169000.0
Cac0_12_2 nac0_12_2 0 0.02p
Rac0_12_3 nac0_12_2 nac0_12_3 169000.0
Cac0_12_3 nac0_12_3 0 0.02p
Rac0_12_4 nac0_12_3 nac0_12_4 169000.0
Cac0_12_4 nac0_12_4 0 0.02p
Rac0_12_5 nac0_12_4 a 169000.0
Rac0_13_0 ac0in nac0_13_0 169000.0
Cac0_13_0 nac0_13_0 0 0.02p
Rac0_13_1 nac0_13_0 nac0_13_1 169000.0
Cac0_13_1 nac0_13_1 0 0.02p
Rac0_13_2 nac0_13_1 nac0_13_2 169000.0
Cac0_13_2 nac0_13_2 0 0.02p
Rac0_13_3 nac0_13_2 nac0_13_3 169000.0
Cac0_13_3 nac0_13_3 0 0.02p
Rac0_13_4 nac0_13_3 nac0_13_4 169000.0
Cac0_13_4 nac0_13_4 0 0.02p
Rac0_13_5 nac0_13_4 a 169000.0
Rac0_14_0 ac0in nac0_14_0 169000.0
Cac0_14_0 nac0_14_0 0 0.02p
Rac0_14_1 nac0_14_0 nac0_14_1 169000.0
Cac0_14_1 nac0_14_1 0 0.02p
Rac0_14_2 nac0_14_1 nac0_14_2 169000.0
Cac0_14_2 nac0_14_2 0 0.02p
Rac0_14_3 nac0_14_2 nac0_14_3 169000.0
Cac0_14_3 nac0_14_3 0 0.02p
Rac0_14_4 nac0_14_3 nac0_14_4 169000.0
Cac0_14_4 nac0_14_4 0 0.02p
Rac0_14_5 nac0_14_4 a 169000.0
Rac0_15_0 ac0in nac0_15_0 169000.0
Cac0_15_0 nac0_15_0 0 0.02p
Rac0_15_1 nac0_15_0 nac0_15_1 169000.0
Cac0_15_1 nac0_15_1 0 0.02p
Rac0_15_2 nac0_15_1 nac0_15_2 169000.0
Cac0_15_2 nac0_15_2 0 0.02p
Rac0_15_3 nac0_15_2 nac0_15_3 169000.0
Cac0_15_3 nac0_15_3 0 0.02p
Rac0_15_4 nac0_15_3 nac0_15_4 169000.0
Cac0_15_4 nac0_15_4 0 0.02p
Rac0_15_5 nac0_15_4 a 169000.0
Rac0_16_0 ac0in nac0_16_0 169000.0
Cac0_16_0 nac0_16_0 0 0.02p
Rac0_16_1 nac0_16_0 nac0_16_1 169000.0
Cac0_16_1 nac0_16_1 0 0.02p
Rac0_16_2 nac0_16_1 nac0_16_2 169000.0
Cac0_16_2 nac0_16_2 0 0.02p
Rac0_16_3 nac0_16_2 nac0_16_3 169000.0
Cac0_16_3 nac0_16_3 0 0.02p
Rac0_16_4 nac0_16_3 nac0_16_4 169000.0
Cac0_16_4 nac0_16_4 0 0.02p
Rac0_16_5 nac0_16_4 a 169000.0
Rac0_17_0 ac0in nac0_17_0 169000.0
Cac0_17_0 nac0_17_0 0 0.02p
Rac0_17_1 nac0_17_0 nac0_17_1 169000.0
Cac0_17_1 nac0_17_1 0 0.02p
Rac0_17_2 nac0_17_1 nac0_17_2 169000.0
Cac0_17_2 nac0_17_2 0 0.02p
Rac0_17_3 nac0_17_2 nac0_17_3 169000.0
Cac0_17_3 nac0_17_3 0 0.02p
Rac0_17_4 nac0_17_3 nac0_17_4 169000.0
Cac0_17_4 nac0_17_4 0 0.02p
Rac0_17_5 nac0_17_4 a 169000.0
Rac0_18_0 ac0in nac0_18_0 169000.0
Cac0_18_0 nac0_18_0 0 0.02p
Rac0_18_1 nac0_18_0 nac0_18_1 169000.0
Cac0_18_1 nac0_18_1 0 0.02p
Rac0_18_2 nac0_18_1 nac0_18_2 169000.0
Cac0_18_2 nac0_18_2 0 0.02p
Rac0_18_3 nac0_18_2 nac0_18_3 169000.0
Cac0_18_3 nac0_18_3 0 0.02p
Rac0_18_4 nac0_18_3 nac0_18_4 169000.0
Cac0_18_4 nac0_18_4 0 0.02p
Rac0_18_5 nac0_18_4 a 169000.0
Rac0_19_0 ac0in nac0_19_0 169000.0
Cac0_19_0 nac0_19_0 0 0.02p
Rac0_19_1 nac0_19_0 nac0_19_1 169000.0
Cac0_19_1 nac0_19_1 0 0.02p
Rac0_19_2 nac0_19_1 nac0_19_2 169000.0
Cac0_19_2 nac0_19_2 0 0.02p
Rac0_19_3 nac0_19_2 nac0_19_3 169000.0
Cac0_19_3 nac0_19_3 0 0.02p
Rac0_19_4 nac0_19_3 nac0_19_4 169000.0
Cac0_19_4 nac0_19_4 0 0.02p
Rac0_19_5 nac0_19_4 a 169000.0
Rac0_20_0 ac0in nac0_20_0 169000.0
Cac0_20_0 nac0_20_0 0 0.02p
Rac0_20_1 nac0_20_0 nac0_20_1 169000.0
Cac0_20_1 nac0_20_1 0 0.02p
Rac0_20_2 nac0_20_1 nac0_20_2 169000.0
Cac0_20_2 nac0_20_2 0 0.02p
Rac0_20_3 nac0_20_2 nac0_20_3 169000.0
Cac0_20_3 nac0_20_3 0 0.02p
Rac0_20_4 nac0_20_3 nac0_20_4 169000.0
Cac0_20_4 nac0_20_4 0 0.02p
Rac0_20_5 nac0_20_4 a 169000.0
Rac0_21_0 ac0in nac0_21_0 169000.0
Cac0_21_0 nac0_21_0 0 0.02p
Rac0_21_1 nac0_21_0 nac0_21_1 169000.0
Cac0_21_1 nac0_21_1 0 0.02p
Rac0_21_2 nac0_21_1 nac0_21_2 169000.0
Cac0_21_2 nac0_21_2 0 0.02p
Rac0_21_3 nac0_21_2 nac0_21_3 169000.0
Cac0_21_3 nac0_21_3 0 0.02p
Rac0_21_4 nac0_21_3 nac0_21_4 169000.0
Cac0_21_4 nac0_21_4 0 0.02p
Rac0_21_5 nac0_21_4 a 169000.0
Rac0_22_0 ac0in nac0_22_0 169000.0
Cac0_22_0 nac0_22_0 0 0.02p
Rac0_22_1 nac0_22_0 nac0_22_1 169000.0
Cac0_22_1 nac0_22_1 0 0.02p
Rac0_22_2 nac0_22_1 nac0_22_2 169000.0
Cac0_22_2 nac0_22_2 0 0.02p
Rac0_22_3 nac0_22_2 nac0_22_3 169000.0
Cac0_22_3 nac0_22_3 0 0.02p
Rac0_22_4 nac0_22_3 nac0_22_4 169000.0
Cac0_22_4 nac0_22_4 0 0.02p
Rac0_22_5 nac0_22_4 a 169000.0
Rac0_23_0 ac0in nac0_23_0 169000.0
Cac0_23_0 nac0_23_0 0 0.02p
Rac0_23_1 nac0_23_0 nac0_23_1 169000.0
Cac0_23_1 nac0_23_1 0 0.02p
Rac0_23_2 nac0_23_1 nac0_23_2 169000.0
Cac0_23_2 nac0_23_2 0 0.02p
Rac0_23_3 nac0_23_2 nac0_23_3 169000.0
Cac0_23_3 nac0_23_3 0 0.02p
Rac0_23_4 nac0_23_3 nac0_23_4 169000.0
Cac0_23_4 nac0_23_4 0 0.02p
Rac0_23_5 nac0_23_4 a 169000.0
Vac1 ac1in 0 DC 0 AC 0.5
Rac1_0_0 ac1in nac1_0_0 169000.0
Cac1_0_0 nac1_0_0 0 0.02p
Rac1_0_1 nac1_0_0 nac1_0_1 169000.0
Cac1_0_1 nac1_0_1 0 0.02p
Rac1_0_2 nac1_0_1 nac1_0_2 169000.0
Cac1_0_2 nac1_0_2 0 0.02p
Rac1_0_3 nac1_0_2 nac1_0_3 169000.0
Cac1_0_3 nac1_0_3 0 0.02p
Rac1_0_4 nac1_0_3 nac1_0_4 169000.0
Cac1_0_4 nac1_0_4 0 0.02p
Rac1_0_5 nac1_0_4 a 169000.0
Rac1_1_0 ac1in nac1_1_0 169000.0
Cac1_1_0 nac1_1_0 0 0.02p
Rac1_1_1 nac1_1_0 nac1_1_1 169000.0
Cac1_1_1 nac1_1_1 0 0.02p
Rac1_1_2 nac1_1_1 nac1_1_2 169000.0
Cac1_1_2 nac1_1_2 0 0.02p
Rac1_1_3 nac1_1_2 nac1_1_3 169000.0
Cac1_1_3 nac1_1_3 0 0.02p
Rac1_1_4 nac1_1_3 nac1_1_4 169000.0
Cac1_1_4 nac1_1_4 0 0.02p
Rac1_1_5 nac1_1_4 a 169000.0
Rac1_2_0 ac1in nac1_2_0 169000.0
Cac1_2_0 nac1_2_0 0 0.02p
Rac1_2_1 nac1_2_0 nac1_2_1 169000.0
Cac1_2_1 nac1_2_1 0 0.02p
Rac1_2_2 nac1_2_1 nac1_2_2 169000.0
Cac1_2_2 nac1_2_2 0 0.02p
Rac1_2_3 nac1_2_2 nac1_2_3 169000.0
Cac1_2_3 nac1_2_3 0 0.02p
Rac1_2_4 nac1_2_3 nac1_2_4 169000.0
Cac1_2_4 nac1_2_4 0 0.02p
Rac1_2_5 nac1_2_4 a 169000.0
Rac1_3_0 ac1in nac1_3_0 169000.0
Cac1_3_0 nac1_3_0 0 0.02p
Rac1_3_1 nac1_3_0 nac1_3_1 169000.0
Cac1_3_1 nac1_3_1 0 0.02p
Rac1_3_2 nac1_3_1 nac1_3_2 169000.0
Cac1_3_2 nac1_3_2 0 0.02p
Rac1_3_3 nac1_3_2 nac1_3_3 169000.0
Cac1_3_3 nac1_3_3 0 0.02p
Rac1_3_4 nac1_3_3 nac1_3_4 169000.0
Cac1_3_4 nac1_3_4 0 0.02p
Rac1_3_5 nac1_3_4 a 169000.0
Rac1_4_0 ac1in nac1_4_0 169000.0
Cac1_4_0 nac1_4_0 0 0.02p
Rac1_4_1 nac1_4_0 nac1_4_1 169000.0
Cac1_4_1 nac1_4_1 0 0.02p
Rac1_4_2 nac1_4_1 nac1_4_2 169000.0
Cac1_4_2 nac1_4_2 0 0.02p
Rac1_4_3 nac1_4_2 nac1_4_3 169000.0
Cac1_4_3 nac1_4_3 0 0.02p
Rac1_4_4 nac1_4_3 nac1_4_4 169000.0
Cac1_4_4 nac1_4_4 0 0.02p
Rac1_4_5 nac1_4_4 a 169000.0
Rac1_5_0 ac1in nac1_5_0 169000.0
Cac1_5_0 nac1_5_0 0 0.02p
Rac1_5_1 nac1_5_0 nac1_5_1 169000.0
Cac1_5_1 nac1_5_1 0 0.02p
Rac1_5_2 nac1_5_1 nac1_5_2 169000.0
Cac1_5_2 nac1_5_2 0 0.02p
Rac1_5_3 nac1_5_2 nac1_5_3 169000.0
Cac1_5_3 nac1_5_3 0 0.02p
Rac1_5_4 nac1_5_3 nac1_5_4 169000.0
Cac1_5_4 nac1_5_4 0 0.02p
Rac1_5_5 nac1_5_4 a 169000.0
Rac1_6_0 ac1in nac1_6_0 169000.0
Cac1_6_0 nac1_6_0 0 0.02p
Rac1_6_1 nac1_6_0 nac1_6_1 169000.0
Cac1_6_1 nac1_6_1 0 0.02p
Rac1_6_2 nac1_6_1 nac1_6_2 169000.0
Cac1_6_2 nac1_6_2 0 0.02p
Rac1_6_3 nac1_6_2 nac1_6_3 169000.0
Cac1_6_3 nac1_6_3 0 0.02p
Rac1_6_4 nac1_6_3 nac1_6_4 169000.0
Cac1_6_4 nac1_6_4 0 0.02p
Rac1_6_5 nac1_6_4 a 169000.0
Rac1_7_0 ac1in nac1_7_0 169000.0
Cac1_7_0 nac1_7_0 0 0.02p
Rac1_7_1 nac1_7_0 nac1_7_1 169000.0
Cac1_7_1 nac1_7_1 0 0.02p
Rac1_7_2 nac1_7_1 nac1_7_2 169000.0
Cac1_7_2 nac1_7_2 0 0.02p
Rac1_7_3 nac1_7_2 nac1_7_3 169000.0
Cac1_7_3 nac1_7_3 0 0.02p
Rac1_7_4 nac1_7_3 nac1_7_4 169000.0
Cac1_7_4 nac1_7_4 0 0.02p
Rac1_7_5 nac1_7_4 a 169000.0
Rac1_8_0 ac1in nac1_8_0 169000.0
Cac1_8_0 nac1_8_0 0 0.02p
Rac1_8_1 nac1_8_0 nac1_8_1 169000.0
Cac1_8_1 nac1_8_1 0 0.02p
Rac1_8_2 nac1_8_1 nac1_8_2 169000.0
Cac1_8_2 nac1_8_2 0 0.02p
Rac1_8_3 nac1_8_2 nac1_8_3 169000.0
Cac1_8_3 nac1_8_3 0 0.02p
Rac1_8_4 nac1_8_3 nac1_8_4 169000.0
Cac1_8_4 nac1_8_4 0 0.02p
Rac1_8_5 nac1_8_4 a 169000.0
Rac1_9_0 ac1in nac1_9_0 169000.0
Cac1_9_0 nac1_9_0 0 0.02p
Rac1_9_1 nac1_9_0 nac1_9_1 169000.0
Cac1_9_1 nac1_9_1 0 0.02p
Rac1_9_2 nac1_9_1 nac1_9_2 169000.0
Cac1_9_2 nac1_9_2 0 0.02p
Rac1_9_3 nac1_9_2 nac1_9_3 169000.0
Cac1_9_3 nac1_9_3 0 0.02p
Rac1_9_4 nac1_9_3 nac1_9_4 169000.0
Cac1_9_4 nac1_9_4 0 0.02p
Rac1_9_5 nac1_9_4 a 169000.0
Rac1_10_0 ac1in nac1_10_0 169000.0
Cac1_10_0 nac1_10_0 0 0.02p
Rac1_10_1 nac1_10_0 nac1_10_1 169000.0
Cac1_10_1 nac1_10_1 0 0.02p
Rac1_10_2 nac1_10_1 nac1_10_2 169000.0
Cac1_10_2 nac1_10_2 0 0.02p
Rac1_10_3 nac1_10_2 nac1_10_3 169000.0
Cac1_10_3 nac1_10_3 0 0.02p
Rac1_10_4 nac1_10_3 nac1_10_4 169000.0
Cac1_10_4 nac1_10_4 0 0.02p
Rac1_10_5 nac1_10_4 a 169000.0
Rac1_11_0 ac1in nac1_11_0 169000.0
Cac1_11_0 nac1_11_0 0 0.02p
Rac1_11_1 nac1_11_0 nac1_11_1 169000.0
Cac1_11_1 nac1_11_1 0 0.02p
Rac1_11_2 nac1_11_1 nac1_11_2 169000.0
Cac1_11_2 nac1_11_2 0 0.02p
Rac1_11_3 nac1_11_2 nac1_11_3 169000.0
Cac1_11_3 nac1_11_3 0 0.02p
Rac1_11_4 nac1_11_3 nac1_11_4 169000.0
Cac1_11_4 nac1_11_4 0 0.02p
Rac1_11_5 nac1_11_4 a 169000.0
Rac1_12_0 ac1in nac1_12_0 169000.0
Cac1_12_0 nac1_12_0 0 0.02p
Rac1_12_1 nac1_12_0 nac1_12_1 169000.0
Cac1_12_1 nac1_12_1 0 0.02p
Rac1_12_2 nac1_12_1 nac1_12_2 169000.0
Cac1_12_2 nac1_12_2 0 0.02p
Rac1_12_3 nac1_12_2 nac1_12_3 169000.0
Cac1_12_3 nac1_12_3 0 0.02p
Rac1_12_4 nac1_12_3 nac1_12_4 169000.0
Cac1_12_4 nac1_12_4 0 0.02p
Rac1_12_5 nac1_12_4 a 169000.0
Rac1_13_0 ac1in nac1_13_0 169000.0
Cac1_13_0 nac1_13_0 0 0.02p
Rac1_13_1 nac1_13_0 nac1_13_1 169000.0
Cac1_13_1 nac1_13_1 0 0.02p
Rac1_13_2 nac1_13_1 nac1_13_2 169000.0
Cac1_13_2 nac1_13_2 0 0.02p
Rac1_13_3 nac1_13_2 nac1_13_3 169000.0
Cac1_13_3 nac1_13_3 0 0.02p
Rac1_13_4 nac1_13_3 nac1_13_4 169000.0
Cac1_13_4 nac1_13_4 0 0.02p
Rac1_13_5 nac1_13_4 a 169000.0
Rac1_14_0 ac1in nac1_14_0 169000.0
Cac1_14_0 nac1_14_0 0 0.02p
Rac1_14_1 nac1_14_0 nac1_14_1 169000.0
Cac1_14_1 nac1_14_1 0 0.02p
Rac1_14_2 nac1_14_1 nac1_14_2 169000.0
Cac1_14_2 nac1_14_2 0 0.02p
Rac1_14_3 nac1_14_2 nac1_14_3 169000.0
Cac1_14_3 nac1_14_3 0 0.02p
Rac1_14_4 nac1_14_3 nac1_14_4 169000.0
Cac1_14_4 nac1_14_4 0 0.02p
Rac1_14_5 nac1_14_4 a 169000.0
Rac1_15_0 ac1in nac1_15_0 169000.0
Cac1_15_0 nac1_15_0 0 0.02p
Rac1_15_1 nac1_15_0 nac1_15_1 169000.0
Cac1_15_1 nac1_15_1 0 0.02p
Rac1_15_2 nac1_15_1 nac1_15_2 169000.0
Cac1_15_2 nac1_15_2 0 0.02p
Rac1_15_3 nac1_15_2 nac1_15_3 169000.0
Cac1_15_3 nac1_15_3 0 0.02p
Rac1_15_4 nac1_15_3 nac1_15_4 169000.0
Cac1_15_4 nac1_15_4 0 0.02p
Rac1_15_5 nac1_15_4 a 169000.0
Rac1_16_0 ac1in nac1_16_0 169000.0
Cac1_16_0 nac1_16_0 0 0.02p
Rac1_16_1 nac1_16_0 nac1_16_1 169000.0
Cac1_16_1 nac1_16_1 0 0.02p
Rac1_16_2 nac1_16_1 nac1_16_2 169000.0
Cac1_16_2 nac1_16_2 0 0.02p
Rac1_16_3 nac1_16_2 nac1_16_3 169000.0
Cac1_16_3 nac1_16_3 0 0.02p
Rac1_16_4 nac1_16_3 nac1_16_4 169000.0
Cac1_16_4 nac1_16_4 0 0.02p
Rac1_16_5 nac1_16_4 a 169000.0
Rac1_17_0 ac1in nac1_17_0 169000.0
Cac1_17_0 nac1_17_0 0 0.02p
Rac1_17_1 nac1_17_0 nac1_17_1 169000.0
Cac1_17_1 nac1_17_1 0 0.02p
Rac1_17_2 nac1_17_1 nac1_17_2 169000.0
Cac1_17_2 nac1_17_2 0 0.02p
Rac1_17_3 nac1_17_2 nac1_17_3 169000.0
Cac1_17_3 nac1_17_3 0 0.02p
Rac1_17_4 nac1_17_3 nac1_17_4 169000.0
Cac1_17_4 nac1_17_4 0 0.02p
Rac1_17_5 nac1_17_4 a 169000.0
Rac1_18_0 ac1in nac1_18_0 169000.0
Cac1_18_0 nac1_18_0 0 0.02p
Rac1_18_1 nac1_18_0 nac1_18_1 169000.0
Cac1_18_1 nac1_18_1 0 0.02p
Rac1_18_2 nac1_18_1 nac1_18_2 169000.0
Cac1_18_2 nac1_18_2 0 0.02p
Rac1_18_3 nac1_18_2 nac1_18_3 169000.0
Cac1_18_3 nac1_18_3 0 0.02p
Rac1_18_4 nac1_18_3 nac1_18_4 169000.0
Cac1_18_4 nac1_18_4 0 0.02p
Rac1_18_5 nac1_18_4 a 169000.0
Rac1_19_0 ac1in nac1_19_0 169000.0
Cac1_19_0 nac1_19_0 0 0.02p
Rac1_19_1 nac1_19_0 nac1_19_1 169000.0
Cac1_19_1 nac1_19_1 0 0.02p
Rac1_19_2 nac1_19_1 nac1_19_2 169000.0
Cac1_19_2 nac1_19_2 0 0.02p
Rac1_19_3 nac1_19_2 nac1_19_3 169000.0
Cac1_19_3 nac1_19_3 0 0.02p
Rac1_19_4 nac1_19_3 nac1_19_4 169000.0
Cac1_19_4 nac1_19_4 0 0.02p
Rac1_19_5 nac1_19_4 a 169000.0
Rac1_20_0 ac1in nac1_20_0 169000.0
Cac1_20_0 nac1_20_0 0 0.02p
Rac1_20_1 nac1_20_0 nac1_20_1 169000.0
Cac1_20_1 nac1_20_1 0 0.02p
Rac1_20_2 nac1_20_1 nac1_20_2 169000.0
Cac1_20_2 nac1_20_2 0 0.02p
Rac1_20_3 nac1_20_2 nac1_20_3 169000.0
Cac1_20_3 nac1_20_3 0 0.02p
Rac1_20_4 nac1_20_3 nac1_20_4 169000.0
Cac1_20_4 nac1_20_4 0 0.02p
Rac1_20_5 nac1_20_4 a 169000.0
Rac1_21_0 ac1in nac1_21_0 169000.0
Cac1_21_0 nac1_21_0 0 0.02p
Rac1_21_1 nac1_21_0 nac1_21_1 169000.0
Cac1_21_1 nac1_21_1 0 0.02p
Rac1_21_2 nac1_21_1 nac1_21_2 169000.0
Cac1_21_2 nac1_21_2 0 0.02p
Rac1_21_3 nac1_21_2 nac1_21_3 169000.0
Cac1_21_3 nac1_21_3 0 0.02p
Rac1_21_4 nac1_21_3 nac1_21_4 169000.0
Cac1_21_4 nac1_21_4 0 0.02p
Rac1_21_5 nac1_21_4 a 169000.0
Rac1_22_0 ac1in nac1_22_0 169000.0
Cac1_22_0 nac1_22_0 0 0.02p
Rac1_22_1 nac1_22_0 nac1_22_1 169000.0
Cac1_22_1 nac1_22_1 0 0.02p
Rac1_22_2 nac1_22_1 nac1_22_2 169000.0
Cac1_22_2 nac1_22_2 0 0.02p
Rac1_22_3 nac1_22_2 nac1_22_3 169000.0
Cac1_22_3 nac1_22_3 0 0.02p
Rac1_22_4 nac1_22_3 nac1_22_4 169000.0
Cac1_22_4 nac1_22_4 0 0.02p
Rac1_22_5 nac1_22_4 a 169000.0
Rac1_23_0 ac1in nac1_23_0 169000.0
Cac1_23_0 nac1_23_0 0 0.02p
Rac1_23_1 nac1_23_0 nac1_23_1 169000.0
Cac1_23_1 nac1_23_1 0 0.02p
Rac1_23_2 nac1_23_1 nac1_23_2 169000.0
Cac1_23_2 nac1_23_2 0 0.02p
Rac1_23_3 nac1_23_2 nac1_23_3 169000.0
Cac1_23_3 nac1_23_3 0 0.02p
Rac1_23_4 nac1_23_3 nac1_23_4 169000.0
Cac1_23_4 nac1_23_4 0 0.02p
Rac1_23_5 nac1_23_4 a 169000.0
Vac2 ac2in 0 DC 0 AC 0.5
Rac2_0_0 ac2in nac2_0_0 169000.0
Cac2_0_0 nac2_0_0 0 0.02p
Rac2_0_1 nac2_0_0 nac2_0_1 169000.0
Cac2_0_1 nac2_0_1 0 0.02p
Rac2_0_2 nac2_0_1 nac2_0_2 169000.0
Cac2_0_2 nac2_0_2 0 0.02p
Rac2_0_3 nac2_0_2 nac2_0_3 169000.0
Cac2_0_3 nac2_0_3 0 0.02p
Rac2_0_4 nac2_0_3 nac2_0_4 169000.0
Cac2_0_4 nac2_0_4 0 0.02p
Rac2_0_5 nac2_0_4 a 169000.0
Rac2_1_0 ac2in nac2_1_0 169000.0
Cac2_1_0 nac2_1_0 0 0.02p
Rac2_1_1 nac2_1_0 nac2_1_1 169000.0
Cac2_1_1 nac2_1_1 0 0.02p
Rac2_1_2 nac2_1_1 nac2_1_2 169000.0
Cac2_1_2 nac2_1_2 0 0.02p
Rac2_1_3 nac2_1_2 nac2_1_3 169000.0
Cac2_1_3 nac2_1_3 0 0.02p
Rac2_1_4 nac2_1_3 nac2_1_4 169000.0
Cac2_1_4 nac2_1_4 0 0.02p
Rac2_1_5 nac2_1_4 a 169000.0
Rac2_2_0 ac2in nac2_2_0 169000.0
Cac2_2_0 nac2_2_0 0 0.02p
Rac2_2_1 nac2_2_0 nac2_2_1 169000.0
Cac2_2_1 nac2_2_1 0 0.02p
Rac2_2_2 nac2_2_1 nac2_2_2 169000.0
Cac2_2_2 nac2_2_2 0 0.02p
Rac2_2_3 nac2_2_2 nac2_2_3 169000.0
Cac2_2_3 nac2_2_3 0 0.02p
Rac2_2_4 nac2_2_3 nac2_2_4 169000.0
Cac2_2_4 nac2_2_4 0 0.02p
Rac2_2_5 nac2_2_4 a 169000.0
Rac2_3_0 ac2in nac2_3_0 169000.0
Cac2_3_0 nac2_3_0 0 0.02p
Rac2_3_1 nac2_3_0 nac2_3_1 169000.0
Cac2_3_1 nac2_3_1 0 0.02p
Rac2_3_2 nac2_3_1 nac2_3_2 169000.0
Cac2_3_2 nac2_3_2 0 0.02p
Rac2_3_3 nac2_3_2 nac2_3_3 169000.0
Cac2_3_3 nac2_3_3 0 0.02p
Rac2_3_4 nac2_3_3 nac2_3_4 169000.0
Cac2_3_4 nac2_3_4 0 0.02p
Rac2_3_5 nac2_3_4 a 169000.0
Rac2_4_0 ac2in nac2_4_0 169000.0
Cac2_4_0 nac2_4_0 0 0.02p
Rac2_4_1 nac2_4_0 nac2_4_1 169000.0
Cac2_4_1 nac2_4_1 0 0.02p
Rac2_4_2 nac2_4_1 nac2_4_2 169000.0
Cac2_4_2 nac2_4_2 0 0.02p
Rac2_4_3 nac2_4_2 nac2_4_3 169000.0
Cac2_4_3 nac2_4_3 0 0.02p
Rac2_4_4 nac2_4_3 nac2_4_4 169000.0
Cac2_4_4 nac2_4_4 0 0.02p
Rac2_4_5 nac2_4_4 a 169000.0
Rac2_5_0 ac2in nac2_5_0 169000.0
Cac2_5_0 nac2_5_0 0 0.02p
Rac2_5_1 nac2_5_0 nac2_5_1 169000.0
Cac2_5_1 nac2_5_1 0 0.02p
Rac2_5_2 nac2_5_1 nac2_5_2 169000.0
Cac2_5_2 nac2_5_2 0 0.02p
Rac2_5_3 nac2_5_2 nac2_5_3 169000.0
Cac2_5_3 nac2_5_3 0 0.02p
Rac2_5_4 nac2_5_3 nac2_5_4 169000.0
Cac2_5_4 nac2_5_4 0 0.02p
Rac2_5_5 nac2_5_4 a 169000.0
Rac2_6_0 ac2in nac2_6_0 169000.0
Cac2_6_0 nac2_6_0 0 0.02p
Rac2_6_1 nac2_6_0 nac2_6_1 169000.0
Cac2_6_1 nac2_6_1 0 0.02p
Rac2_6_2 nac2_6_1 nac2_6_2 169000.0
Cac2_6_2 nac2_6_2 0 0.02p
Rac2_6_3 nac2_6_2 nac2_6_3 169000.0
Cac2_6_3 nac2_6_3 0 0.02p
Rac2_6_4 nac2_6_3 nac2_6_4 169000.0
Cac2_6_4 nac2_6_4 0 0.02p
Rac2_6_5 nac2_6_4 a 169000.0
Rac2_7_0 ac2in nac2_7_0 169000.0
Cac2_7_0 nac2_7_0 0 0.02p
Rac2_7_1 nac2_7_0 nac2_7_1 169000.0
Cac2_7_1 nac2_7_1 0 0.02p
Rac2_7_2 nac2_7_1 nac2_7_2 169000.0
Cac2_7_2 nac2_7_2 0 0.02p
Rac2_7_3 nac2_7_2 nac2_7_3 169000.0
Cac2_7_3 nac2_7_3 0 0.02p
Rac2_7_4 nac2_7_3 nac2_7_4 169000.0
Cac2_7_4 nac2_7_4 0 0.02p
Rac2_7_5 nac2_7_4 a 169000.0
Rac2_8_0 ac2in nac2_8_0 169000.0
Cac2_8_0 nac2_8_0 0 0.02p
Rac2_8_1 nac2_8_0 nac2_8_1 169000.0
Cac2_8_1 nac2_8_1 0 0.02p
Rac2_8_2 nac2_8_1 nac2_8_2 169000.0
Cac2_8_2 nac2_8_2 0 0.02p
Rac2_8_3 nac2_8_2 nac2_8_3 169000.0
Cac2_8_3 nac2_8_3 0 0.02p
Rac2_8_4 nac2_8_3 nac2_8_4 169000.0
Cac2_8_4 nac2_8_4 0 0.02p
Rac2_8_5 nac2_8_4 a 169000.0
Rac2_9_0 ac2in nac2_9_0 169000.0
Cac2_9_0 nac2_9_0 0 0.02p
Rac2_9_1 nac2_9_0 nac2_9_1 169000.0
Cac2_9_1 nac2_9_1 0 0.02p
Rac2_9_2 nac2_9_1 nac2_9_2 169000.0
Cac2_9_2 nac2_9_2 0 0.02p
Rac2_9_3 nac2_9_2 nac2_9_3 169000.0
Cac2_9_3 nac2_9_3 0 0.02p
Rac2_9_4 nac2_9_3 nac2_9_4 169000.0
Cac2_9_4 nac2_9_4 0 0.02p
Rac2_9_5 nac2_9_4 a 169000.0
Rac2_10_0 ac2in nac2_10_0 169000.0
Cac2_10_0 nac2_10_0 0 0.02p
Rac2_10_1 nac2_10_0 nac2_10_1 169000.0
Cac2_10_1 nac2_10_1 0 0.02p
Rac2_10_2 nac2_10_1 nac2_10_2 169000.0
Cac2_10_2 nac2_10_2 0 0.02p
Rac2_10_3 nac2_10_2 nac2_10_3 169000.0
Cac2_10_3 nac2_10_3 0 0.02p
Rac2_10_4 nac2_10_3 nac2_10_4 169000.0
Cac2_10_4 nac2_10_4 0 0.02p
Rac2_10_5 nac2_10_4 a 169000.0
Rac2_11_0 ac2in nac2_11_0 169000.0
Cac2_11_0 nac2_11_0 0 0.02p
Rac2_11_1 nac2_11_0 nac2_11_1 169000.0
Cac2_11_1 nac2_11_1 0 0.02p
Rac2_11_2 nac2_11_1 nac2_11_2 169000.0
Cac2_11_2 nac2_11_2 0 0.02p
Rac2_11_3 nac2_11_2 nac2_11_3 169000.0
Cac2_11_3 nac2_11_3 0 0.02p
Rac2_11_4 nac2_11_3 nac2_11_4 169000.0
Cac2_11_4 nac2_11_4 0 0.02p
Rac2_11_5 nac2_11_4 a 169000.0
Rac2_12_0 ac2in nac2_12_0 169000.0
Cac2_12_0 nac2_12_0 0 0.02p
Rac2_12_1 nac2_12_0 nac2_12_1 169000.0
Cac2_12_1 nac2_12_1 0 0.02p
Rac2_12_2 nac2_12_1 nac2_12_2 169000.0
Cac2_12_2 nac2_12_2 0 0.02p
Rac2_12_3 nac2_12_2 nac2_12_3 169000.0
Cac2_12_3 nac2_12_3 0 0.02p
Rac2_12_4 nac2_12_3 nac2_12_4 169000.0
Cac2_12_4 nac2_12_4 0 0.02p
Rac2_12_5 nac2_12_4 a 169000.0
Rac2_13_0 ac2in nac2_13_0 169000.0
Cac2_13_0 nac2_13_0 0 0.02p
Rac2_13_1 nac2_13_0 nac2_13_1 169000.0
Cac2_13_1 nac2_13_1 0 0.02p
Rac2_13_2 nac2_13_1 nac2_13_2 169000.0
Cac2_13_2 nac2_13_2 0 0.02p
Rac2_13_3 nac2_13_2 nac2_13_3 169000.0
Cac2_13_3 nac2_13_3 0 0.02p
Rac2_13_4 nac2_13_3 nac2_13_4 169000.0
Cac2_13_4 nac2_13_4 0 0.02p
Rac2_13_5 nac2_13_4 a 169000.0
Rac2_14_0 ac2in nac2_14_0 169000.0
Cac2_14_0 nac2_14_0 0 0.02p
Rac2_14_1 nac2_14_0 nac2_14_1 169000.0
Cac2_14_1 nac2_14_1 0 0.02p
Rac2_14_2 nac2_14_1 nac2_14_2 169000.0
Cac2_14_2 nac2_14_2 0 0.02p
Rac2_14_3 nac2_14_2 nac2_14_3 169000.0
Cac2_14_3 nac2_14_3 0 0.02p
Rac2_14_4 nac2_14_3 nac2_14_4 169000.0
Cac2_14_4 nac2_14_4 0 0.02p
Rac2_14_5 nac2_14_4 a 169000.0
Rac2_15_0 ac2in nac2_15_0 169000.0
Cac2_15_0 nac2_15_0 0 0.02p
Rac2_15_1 nac2_15_0 nac2_15_1 169000.0
Cac2_15_1 nac2_15_1 0 0.02p
Rac2_15_2 nac2_15_1 nac2_15_2 169000.0
Cac2_15_2 nac2_15_2 0 0.02p
Rac2_15_3 nac2_15_2 nac2_15_3 169000.0
Cac2_15_3 nac2_15_3 0 0.02p
Rac2_15_4 nac2_15_3 nac2_15_4 169000.0
Cac2_15_4 nac2_15_4 0 0.02p
Rac2_15_5 nac2_15_4 a 169000.0
Rac2_16_0 ac2in nac2_16_0 169000.0
Cac2_16_0 nac2_16_0 0 0.02p
Rac2_16_1 nac2_16_0 nac2_16_1 169000.0
Cac2_16_1 nac2_16_1 0 0.02p
Rac2_16_2 nac2_16_1 nac2_16_2 169000.0
Cac2_16_2 nac2_16_2 0 0.02p
Rac2_16_3 nac2_16_2 nac2_16_3 169000.0
Cac2_16_3 nac2_16_3 0 0.02p
Rac2_16_4 nac2_16_3 nac2_16_4 169000.0
Cac2_16_4 nac2_16_4 0 0.02p
Rac2_16_5 nac2_16_4 a 169000.0
Rac2_17_0 ac2in nac2_17_0 169000.0
Cac2_17_0 nac2_17_0 0 0.02p
Rac2_17_1 nac2_17_0 nac2_17_1 169000.0
Cac2_17_1 nac2_17_1 0 0.02p
Rac2_17_2 nac2_17_1 nac2_17_2 169000.0
Cac2_17_2 nac2_17_2 0 0.02p
Rac2_17_3 nac2_17_2 nac2_17_3 169000.0
Cac2_17_3 nac2_17_3 0 0.02p
Rac2_17_4 nac2_17_3 nac2_17_4 169000.0
Cac2_17_4 nac2_17_4 0 0.02p
Rac2_17_5 nac2_17_4 a 169000.0
Rac2_18_0 ac2in nac2_18_0 169000.0
Cac2_18_0 nac2_18_0 0 0.02p
Rac2_18_1 nac2_18_0 nac2_18_1 169000.0
Cac2_18_1 nac2_18_1 0 0.02p
Rac2_18_2 nac2_18_1 nac2_18_2 169000.0
Cac2_18_2 nac2_18_2 0 0.02p
Rac2_18_3 nac2_18_2 nac2_18_3 169000.0
Cac2_18_3 nac2_18_3 0 0.02p
Rac2_18_4 nac2_18_3 nac2_18_4 169000.0
Cac2_18_4 nac2_18_4 0 0.02p
Rac2_18_5 nac2_18_4 a 169000.0
Rac2_19_0 ac2in nac2_19_0 169000.0
Cac2_19_0 nac2_19_0 0 0.02p
Rac2_19_1 nac2_19_0 nac2_19_1 169000.0
Cac2_19_1 nac2_19_1 0 0.02p
Rac2_19_2 nac2_19_1 nac2_19_2 169000.0
Cac2_19_2 nac2_19_2 0 0.02p
Rac2_19_3 nac2_19_2 nac2_19_3 169000.0
Cac2_19_3 nac2_19_3 0 0.02p
Rac2_19_4 nac2_19_3 nac2_19_4 169000.0
Cac2_19_4 nac2_19_4 0 0.02p
Rac2_19_5 nac2_19_4 a 169000.0
Rac2_20_0 ac2in nac2_20_0 169000.0
Cac2_20_0 nac2_20_0 0 0.02p
Rac2_20_1 nac2_20_0 nac2_20_1 169000.0
Cac2_20_1 nac2_20_1 0 0.02p
Rac2_20_2 nac2_20_1 nac2_20_2 169000.0
Cac2_20_2 nac2_20_2 0 0.02p
Rac2_20_3 nac2_20_2 nac2_20_3 169000.0
Cac2_20_3 nac2_20_3 0 0.02p
Rac2_20_4 nac2_20_3 nac2_20_4 169000.0
Cac2_20_4 nac2_20_4 0 0.02p
Rac2_20_5 nac2_20_4 a 169000.0
Rac2_21_0 ac2in nac2_21_0 169000.0
Cac2_21_0 nac2_21_0 0 0.02p
Rac2_21_1 nac2_21_0 nac2_21_1 169000.0
Cac2_21_1 nac2_21_1 0 0.02p
Rac2_21_2 nac2_21_1 nac2_21_2 169000.0
Cac2_21_2 nac2_21_2 0 0.02p
Rac2_21_3 nac2_21_2 nac2_21_3 169000.0
Cac2_21_3 nac2_21_3 0 0.02p
Rac2_21_4 nac2_21_3 nac2_21_4 169000.0
Cac2_21_4 nac2_21_4 0 0.02p
Rac2_21_5 nac2_21_4 a 169000.0
Rac2_22_0 ac2in nac2_22_0 169000.0
Cac2_22_0 nac2_22_0 0 0.02p
Rac2_22_1 nac2_22_0 nac2_22_1 169000.0
Cac2_22_1 nac2_22_1 0 0.02p
Rac2_22_2 nac2_22_1 nac2_22_2 169000.0
Cac2_22_2 nac2_22_2 0 0.02p
Rac2_22_3 nac2_22_2 nac2_22_3 169000.0
Cac2_22_3 nac2_22_3 0 0.02p
Rac2_22_4 nac2_22_3 nac2_22_4 169000.0
Cac2_22_4 nac2_22_4 0 0.02p
Rac2_22_5 nac2_22_4 a 169000.0
Rac2_23_0 ac2in nac2_23_0 169000.0
Cac2_23_0 nac2_23_0 0 0.02p
Rac2_23_1 nac2_23_0 nac2_23_1 169000.0
Cac2_23_1 nac2_23_1 0 0.02p
Rac2_23_2 nac2_23_1 nac2_23_2 169000.0
Cac2_23_2 nac2_23_2 0 0.02p
Rac2_23_3 nac2_23_2 nac2_23_3 169000.0
Cac2_23_3 nac2_23_3 0 0.02p
Rac2_23_4 nac2_23_3 nac2_23_4 169000.0
Cac2_23_4 nac2_23_4 0 0.02p
Rac2_23_5 nac2_23_4 a 169000.0
Vac3 ac3in 0 DC 0 AC 0.5
Rac3_0_0 ac3in nac3_0_0 169000.0
Cac3_0_0 nac3_0_0 0 0.02p
Rac3_0_1 nac3_0_0 nac3_0_1 169000.0
Cac3_0_1 nac3_0_1 0 0.02p
Rac3_0_2 nac3_0_1 nac3_0_2 169000.0
Cac3_0_2 nac3_0_2 0 0.02p
Rac3_0_3 nac3_0_2 nac3_0_3 169000.0
Cac3_0_3 nac3_0_3 0 0.02p
Rac3_0_4 nac3_0_3 nac3_0_4 169000.0
Cac3_0_4 nac3_0_4 0 0.02p
Rac3_0_5 nac3_0_4 a 169000.0
Rac3_1_0 ac3in nac3_1_0 169000.0
Cac3_1_0 nac3_1_0 0 0.02p
Rac3_1_1 nac3_1_0 nac3_1_1 169000.0
Cac3_1_1 nac3_1_1 0 0.02p
Rac3_1_2 nac3_1_1 nac3_1_2 169000.0
Cac3_1_2 nac3_1_2 0 0.02p
Rac3_1_3 nac3_1_2 nac3_1_3 169000.0
Cac3_1_3 nac3_1_3 0 0.02p
Rac3_1_4 nac3_1_3 nac3_1_4 169000.0
Cac3_1_4 nac3_1_4 0 0.02p
Rac3_1_5 nac3_1_4 a 169000.0
Rac3_2_0 ac3in nac3_2_0 169000.0
Cac3_2_0 nac3_2_0 0 0.02p
Rac3_2_1 nac3_2_0 nac3_2_1 169000.0
Cac3_2_1 nac3_2_1 0 0.02p
Rac3_2_2 nac3_2_1 nac3_2_2 169000.0
Cac3_2_2 nac3_2_2 0 0.02p
Rac3_2_3 nac3_2_2 nac3_2_3 169000.0
Cac3_2_3 nac3_2_3 0 0.02p
Rac3_2_4 nac3_2_3 nac3_2_4 169000.0
Cac3_2_4 nac3_2_4 0 0.02p
Rac3_2_5 nac3_2_4 a 169000.0
Rac3_3_0 ac3in nac3_3_0 169000.0
Cac3_3_0 nac3_3_0 0 0.02p
Rac3_3_1 nac3_3_0 nac3_3_1 169000.0
Cac3_3_1 nac3_3_1 0 0.02p
Rac3_3_2 nac3_3_1 nac3_3_2 169000.0
Cac3_3_2 nac3_3_2 0 0.02p
Rac3_3_3 nac3_3_2 nac3_3_3 169000.0
Cac3_3_3 nac3_3_3 0 0.02p
Rac3_3_4 nac3_3_3 nac3_3_4 169000.0
Cac3_3_4 nac3_3_4 0 0.02p
Rac3_3_5 nac3_3_4 a 169000.0
Rac3_4_0 ac3in nac3_4_0 169000.0
Cac3_4_0 nac3_4_0 0 0.02p
Rac3_4_1 nac3_4_0 nac3_4_1 169000.0
Cac3_4_1 nac3_4_1 0 0.02p
Rac3_4_2 nac3_4_1 nac3_4_2 169000.0
Cac3_4_2 nac3_4_2 0 0.02p
Rac3_4_3 nac3_4_2 nac3_4_3 169000.0
Cac3_4_3 nac3_4_3 0 0.02p
Rac3_4_4 nac3_4_3 nac3_4_4 169000.0
Cac3_4_4 nac3_4_4 0 0.02p
Rac3_4_5 nac3_4_4 a 169000.0
Rac3_5_0 ac3in nac3_5_0 169000.0
Cac3_5_0 nac3_5_0 0 0.02p
Rac3_5_1 nac3_5_0 nac3_5_1 169000.0
Cac3_5_1 nac3_5_1 0 0.02p
Rac3_5_2 nac3_5_1 nac3_5_2 169000.0
Cac3_5_2 nac3_5_2 0 0.02p
Rac3_5_3 nac3_5_2 nac3_5_3 169000.0
Cac3_5_3 nac3_5_3 0 0.02p
Rac3_5_4 nac3_5_3 nac3_5_4 169000.0
Cac3_5_4 nac3_5_4 0 0.02p
Rac3_5_5 nac3_5_4 a 169000.0
Rac3_6_0 ac3in nac3_6_0 169000.0
Cac3_6_0 nac3_6_0 0 0.02p
Rac3_6_1 nac3_6_0 nac3_6_1 169000.0
Cac3_6_1 nac3_6_1 0 0.02p
Rac3_6_2 nac3_6_1 nac3_6_2 169000.0
Cac3_6_2 nac3_6_2 0 0.02p
Rac3_6_3 nac3_6_2 nac3_6_3 169000.0
Cac3_6_3 nac3_6_3 0 0.02p
Rac3_6_4 nac3_6_3 nac3_6_4 169000.0
Cac3_6_4 nac3_6_4 0 0.02p
Rac3_6_5 nac3_6_4 a 169000.0
Rac3_7_0 ac3in nac3_7_0 169000.0
Cac3_7_0 nac3_7_0 0 0.02p
Rac3_7_1 nac3_7_0 nac3_7_1 169000.0
Cac3_7_1 nac3_7_1 0 0.02p
Rac3_7_2 nac3_7_1 nac3_7_2 169000.0
Cac3_7_2 nac3_7_2 0 0.02p
Rac3_7_3 nac3_7_2 nac3_7_3 169000.0
Cac3_7_3 nac3_7_3 0 0.02p
Rac3_7_4 nac3_7_3 nac3_7_4 169000.0
Cac3_7_4 nac3_7_4 0 0.02p
Rac3_7_5 nac3_7_4 a 169000.0
Rac3_8_0 ac3in nac3_8_0 169000.0
Cac3_8_0 nac3_8_0 0 0.02p
Rac3_8_1 nac3_8_0 nac3_8_1 169000.0
Cac3_8_1 nac3_8_1 0 0.02p
Rac3_8_2 nac3_8_1 nac3_8_2 169000.0
Cac3_8_2 nac3_8_2 0 0.02p
Rac3_8_3 nac3_8_2 nac3_8_3 169000.0
Cac3_8_3 nac3_8_3 0 0.02p
Rac3_8_4 nac3_8_3 nac3_8_4 169000.0
Cac3_8_4 nac3_8_4 0 0.02p
Rac3_8_5 nac3_8_4 a 169000.0
Rac3_9_0 ac3in nac3_9_0 169000.0
Cac3_9_0 nac3_9_0 0 0.02p
Rac3_9_1 nac3_9_0 nac3_9_1 169000.0
Cac3_9_1 nac3_9_1 0 0.02p
Rac3_9_2 nac3_9_1 nac3_9_2 169000.0
Cac3_9_2 nac3_9_2 0 0.02p
Rac3_9_3 nac3_9_2 nac3_9_3 169000.0
Cac3_9_3 nac3_9_3 0 0.02p
Rac3_9_4 nac3_9_3 nac3_9_4 169000.0
Cac3_9_4 nac3_9_4 0 0.02p
Rac3_9_5 nac3_9_4 a 169000.0
Rac3_10_0 ac3in nac3_10_0 169000.0
Cac3_10_0 nac3_10_0 0 0.02p
Rac3_10_1 nac3_10_0 nac3_10_1 169000.0
Cac3_10_1 nac3_10_1 0 0.02p
Rac3_10_2 nac3_10_1 nac3_10_2 169000.0
Cac3_10_2 nac3_10_2 0 0.02p
Rac3_10_3 nac3_10_2 nac3_10_3 169000.0
Cac3_10_3 nac3_10_3 0 0.02p
Rac3_10_4 nac3_10_3 nac3_10_4 169000.0
Cac3_10_4 nac3_10_4 0 0.02p
Rac3_10_5 nac3_10_4 a 169000.0
Rac3_11_0 ac3in nac3_11_0 169000.0
Cac3_11_0 nac3_11_0 0 0.02p
Rac3_11_1 nac3_11_0 nac3_11_1 169000.0
Cac3_11_1 nac3_11_1 0 0.02p
Rac3_11_2 nac3_11_1 nac3_11_2 169000.0
Cac3_11_2 nac3_11_2 0 0.02p
Rac3_11_3 nac3_11_2 nac3_11_3 169000.0
Cac3_11_3 nac3_11_3 0 0.02p
Rac3_11_4 nac3_11_3 nac3_11_4 169000.0
Cac3_11_4 nac3_11_4 0 0.02p
Rac3_11_5 nac3_11_4 a 169000.0
Rac3_12_0 ac3in nac3_12_0 169000.0
Cac3_12_0 nac3_12_0 0 0.02p
Rac3_12_1 nac3_12_0 nac3_12_1 169000.0
Cac3_12_1 nac3_12_1 0 0.02p
Rac3_12_2 nac3_12_1 nac3_12_2 169000.0
Cac3_12_2 nac3_12_2 0 0.02p
Rac3_12_3 nac3_12_2 nac3_12_3 169000.0
Cac3_12_3 nac3_12_3 0 0.02p
Rac3_12_4 nac3_12_3 nac3_12_4 169000.0
Cac3_12_4 nac3_12_4 0 0.02p
Rac3_12_5 nac3_12_4 a 169000.0
Rac3_13_0 ac3in nac3_13_0 169000.0
Cac3_13_0 nac3_13_0 0 0.02p
Rac3_13_1 nac3_13_0 nac3_13_1 169000.0
Cac3_13_1 nac3_13_1 0 0.02p
Rac3_13_2 nac3_13_1 nac3_13_2 169000.0
Cac3_13_2 nac3_13_2 0 0.02p
Rac3_13_3 nac3_13_2 nac3_13_3 169000.0
Cac3_13_3 nac3_13_3 0 0.02p
Rac3_13_4 nac3_13_3 nac3_13_4 169000.0
Cac3_13_4 nac3_13_4 0 0.02p
Rac3_13_5 nac3_13_4 a 169000.0
Rac3_14_0 ac3in nac3_14_0 169000.0
Cac3_14_0 nac3_14_0 0 0.02p
Rac3_14_1 nac3_14_0 nac3_14_1 169000.0
Cac3_14_1 nac3_14_1 0 0.02p
Rac3_14_2 nac3_14_1 nac3_14_2 169000.0
Cac3_14_2 nac3_14_2 0 0.02p
Rac3_14_3 nac3_14_2 nac3_14_3 169000.0
Cac3_14_3 nac3_14_3 0 0.02p
Rac3_14_4 nac3_14_3 nac3_14_4 169000.0
Cac3_14_4 nac3_14_4 0 0.02p
Rac3_14_5 nac3_14_4 a 169000.0
Rac3_15_0 ac3in nac3_15_0 169000.0
Cac3_15_0 nac3_15_0 0 0.02p
Rac3_15_1 nac3_15_0 nac3_15_1 169000.0
Cac3_15_1 nac3_15_1 0 0.02p
Rac3_15_2 nac3_15_1 nac3_15_2 169000.0
Cac3_15_2 nac3_15_2 0 0.02p
Rac3_15_3 nac3_15_2 nac3_15_3 169000.0
Cac3_15_3 nac3_15_3 0 0.02p
Rac3_15_4 nac3_15_3 nac3_15_4 169000.0
Cac3_15_4 nac3_15_4 0 0.02p
Rac3_15_5 nac3_15_4 a 169000.0
Rac3_16_0 ac3in nac3_16_0 169000.0
Cac3_16_0 nac3_16_0 0 0.02p
Rac3_16_1 nac3_16_0 nac3_16_1 169000.0
Cac3_16_1 nac3_16_1 0 0.02p
Rac3_16_2 nac3_16_1 nac3_16_2 169000.0
Cac3_16_2 nac3_16_2 0 0.02p
Rac3_16_3 nac3_16_2 nac3_16_3 169000.0
Cac3_16_3 nac3_16_3 0 0.02p
Rac3_16_4 nac3_16_3 nac3_16_4 169000.0
Cac3_16_4 nac3_16_4 0 0.02p
Rac3_16_5 nac3_16_4 a 169000.0
Rac3_17_0 ac3in nac3_17_0 169000.0
Cac3_17_0 nac3_17_0 0 0.02p
Rac3_17_1 nac3_17_0 nac3_17_1 169000.0
Cac3_17_1 nac3_17_1 0 0.02p
Rac3_17_2 nac3_17_1 nac3_17_2 169000.0
Cac3_17_2 nac3_17_2 0 0.02p
Rac3_17_3 nac3_17_2 nac3_17_3 169000.0
Cac3_17_3 nac3_17_3 0 0.02p
Rac3_17_4 nac3_17_3 nac3_17_4 169000.0
Cac3_17_4 nac3_17_4 0 0.02p
Rac3_17_5 nac3_17_4 a 169000.0
Rac3_18_0 ac3in nac3_18_0 169000.0
Cac3_18_0 nac3_18_0 0 0.02p
Rac3_18_1 nac3_18_0 nac3_18_1 169000.0
Cac3_18_1 nac3_18_1 0 0.02p
Rac3_18_2 nac3_18_1 nac3_18_2 169000.0
Cac3_18_2 nac3_18_2 0 0.02p
Rac3_18_3 nac3_18_2 nac3_18_3 169000.0
Cac3_18_3 nac3_18_3 0 0.02p
Rac3_18_4 nac3_18_3 nac3_18_4 169000.0
Cac3_18_4 nac3_18_4 0 0.02p
Rac3_18_5 nac3_18_4 a 169000.0
Rac3_19_0 ac3in nac3_19_0 169000.0
Cac3_19_0 nac3_19_0 0 0.02p
Rac3_19_1 nac3_19_0 nac3_19_1 169000.0
Cac3_19_1 nac3_19_1 0 0.02p
Rac3_19_2 nac3_19_1 nac3_19_2 169000.0
Cac3_19_2 nac3_19_2 0 0.02p
Rac3_19_3 nac3_19_2 nac3_19_3 169000.0
Cac3_19_3 nac3_19_3 0 0.02p
Rac3_19_4 nac3_19_3 nac3_19_4 169000.0
Cac3_19_4 nac3_19_4 0 0.02p
Rac3_19_5 nac3_19_4 a 169000.0
Rac3_20_0 ac3in nac3_20_0 169000.0
Cac3_20_0 nac3_20_0 0 0.02p
Rac3_20_1 nac3_20_0 nac3_20_1 169000.0
Cac3_20_1 nac3_20_1 0 0.02p
Rac3_20_2 nac3_20_1 nac3_20_2 169000.0
Cac3_20_2 nac3_20_2 0 0.02p
Rac3_20_3 nac3_20_2 nac3_20_3 169000.0
Cac3_20_3 nac3_20_3 0 0.02p
Rac3_20_4 nac3_20_3 nac3_20_4 169000.0
Cac3_20_4 nac3_20_4 0 0.02p
Rac3_20_5 nac3_20_4 a 169000.0
Rac3_21_0 ac3in nac3_21_0 169000.0
Cac3_21_0 nac3_21_0 0 0.02p
Rac3_21_1 nac3_21_0 nac3_21_1 169000.0
Cac3_21_1 nac3_21_1 0 0.02p
Rac3_21_2 nac3_21_1 nac3_21_2 169000.0
Cac3_21_2 nac3_21_2 0 0.02p
Rac3_21_3 nac3_21_2 nac3_21_3 169000.0
Cac3_21_3 nac3_21_3 0 0.02p
Rac3_21_4 nac3_21_3 nac3_21_4 169000.0
Cac3_21_4 nac3_21_4 0 0.02p
Rac3_21_5 nac3_21_4 a 169000.0
Rac3_22_0 ac3in nac3_22_0 169000.0
Cac3_22_0 nac3_22_0 0 0.02p
Rac3_22_1 nac3_22_0 nac3_22_1 169000.0
Cac3_22_1 nac3_22_1 0 0.02p
Rac3_22_2 nac3_22_1 nac3_22_2 169000.0
Cac3_22_2 nac3_22_2 0 0.02p
Rac3_22_3 nac3_22_2 nac3_22_3 169000.0
Cac3_22_3 nac3_22_3 0 0.02p
Rac3_22_4 nac3_22_3 nac3_22_4 169000.0
Cac3_22_4 nac3_22_4 0 0.02p
Rac3_22_5 nac3_22_4 a 169000.0
Rac3_23_0 ac3in nac3_23_0 169000.0
Cac3_23_0 nac3_23_0 0 0.02p
Rac3_23_1 nac3_23_0 nac3_23_1 169000.0
Cac3_23_1 nac3_23_1 0 0.02p
Rac3_23_2 nac3_23_1 nac3_23_2 169000.0
Cac3_23_2 nac3_23_2 0 0.02p
Rac3_23_3 nac3_23_2 nac3_23_3 169000.0
Cac3_23_3 nac3_23_3 0 0.02p
Rac3_23_4 nac3_23_3 nac3_23_4 169000.0
Cac3_23_4 nac3_23_4 0 0.02p
Rac3_23_5 nac3_23_4 a 169000.0
Vac4 ac4in 0 DC 0 AC 0.5
Rac4_0_0 ac4in nac4_0_0 169000.0
Cac4_0_0 nac4_0_0 0 0.02p
Rac4_0_1 nac4_0_0 nac4_0_1 169000.0
Cac4_0_1 nac4_0_1 0 0.02p
Rac4_0_2 nac4_0_1 nac4_0_2 169000.0
Cac4_0_2 nac4_0_2 0 0.02p
Rac4_0_3 nac4_0_2 nac4_0_3 169000.0
Cac4_0_3 nac4_0_3 0 0.02p
Rac4_0_4 nac4_0_3 nac4_0_4 169000.0
Cac4_0_4 nac4_0_4 0 0.02p
Rac4_0_5 nac4_0_4 a 169000.0
Rac4_1_0 ac4in nac4_1_0 169000.0
Cac4_1_0 nac4_1_0 0 0.02p
Rac4_1_1 nac4_1_0 nac4_1_1 169000.0
Cac4_1_1 nac4_1_1 0 0.02p
Rac4_1_2 nac4_1_1 nac4_1_2 169000.0
Cac4_1_2 nac4_1_2 0 0.02p
Rac4_1_3 nac4_1_2 nac4_1_3 169000.0
Cac4_1_3 nac4_1_3 0 0.02p
Rac4_1_4 nac4_1_3 nac4_1_4 169000.0
Cac4_1_4 nac4_1_4 0 0.02p
Rac4_1_5 nac4_1_4 a 169000.0
Rac4_2_0 ac4in nac4_2_0 169000.0
Cac4_2_0 nac4_2_0 0 0.02p
Rac4_2_1 nac4_2_0 nac4_2_1 169000.0
Cac4_2_1 nac4_2_1 0 0.02p
Rac4_2_2 nac4_2_1 nac4_2_2 169000.0
Cac4_2_2 nac4_2_2 0 0.02p
Rac4_2_3 nac4_2_2 nac4_2_3 169000.0
Cac4_2_3 nac4_2_3 0 0.02p
Rac4_2_4 nac4_2_3 nac4_2_4 169000.0
Cac4_2_4 nac4_2_4 0 0.02p
Rac4_2_5 nac4_2_4 a 169000.0
Rac4_3_0 ac4in nac4_3_0 169000.0
Cac4_3_0 nac4_3_0 0 0.02p
Rac4_3_1 nac4_3_0 nac4_3_1 169000.0
Cac4_3_1 nac4_3_1 0 0.02p
Rac4_3_2 nac4_3_1 nac4_3_2 169000.0
Cac4_3_2 nac4_3_2 0 0.02p
Rac4_3_3 nac4_3_2 nac4_3_3 169000.0
Cac4_3_3 nac4_3_3 0 0.02p
Rac4_3_4 nac4_3_3 nac4_3_4 169000.0
Cac4_3_4 nac4_3_4 0 0.02p
Rac4_3_5 nac4_3_4 a 169000.0
Rac4_4_0 ac4in nac4_4_0 169000.0
Cac4_4_0 nac4_4_0 0 0.02p
Rac4_4_1 nac4_4_0 nac4_4_1 169000.0
Cac4_4_1 nac4_4_1 0 0.02p
Rac4_4_2 nac4_4_1 nac4_4_2 169000.0
Cac4_4_2 nac4_4_2 0 0.02p
Rac4_4_3 nac4_4_2 nac4_4_3 169000.0
Cac4_4_3 nac4_4_3 0 0.02p
Rac4_4_4 nac4_4_3 nac4_4_4 169000.0
Cac4_4_4 nac4_4_4 0 0.02p
Rac4_4_5 nac4_4_4 a 169000.0
Rac4_5_0 ac4in nac4_5_0 169000.0
Cac4_5_0 nac4_5_0 0 0.02p
Rac4_5_1 nac4_5_0 nac4_5_1 169000.0
Cac4_5_1 nac4_5_1 0 0.02p
Rac4_5_2 nac4_5_1 nac4_5_2 169000.0
Cac4_5_2 nac4_5_2 0 0.02p
Rac4_5_3 nac4_5_2 nac4_5_3 169000.0
Cac4_5_3 nac4_5_3 0 0.02p
Rac4_5_4 nac4_5_3 nac4_5_4 169000.0
Cac4_5_4 nac4_5_4 0 0.02p
Rac4_5_5 nac4_5_4 a 169000.0
Rac4_6_0 ac4in nac4_6_0 169000.0
Cac4_6_0 nac4_6_0 0 0.02p
Rac4_6_1 nac4_6_0 nac4_6_1 169000.0
Cac4_6_1 nac4_6_1 0 0.02p
Rac4_6_2 nac4_6_1 nac4_6_2 169000.0
Cac4_6_2 nac4_6_2 0 0.02p
Rac4_6_3 nac4_6_2 nac4_6_3 169000.0
Cac4_6_3 nac4_6_3 0 0.02p
Rac4_6_4 nac4_6_3 nac4_6_4 169000.0
Cac4_6_4 nac4_6_4 0 0.02p
Rac4_6_5 nac4_6_4 a 169000.0
Rac4_7_0 ac4in nac4_7_0 169000.0
Cac4_7_0 nac4_7_0 0 0.02p
Rac4_7_1 nac4_7_0 nac4_7_1 169000.0
Cac4_7_1 nac4_7_1 0 0.02p
Rac4_7_2 nac4_7_1 nac4_7_2 169000.0
Cac4_7_2 nac4_7_2 0 0.02p
Rac4_7_3 nac4_7_2 nac4_7_3 169000.0
Cac4_7_3 nac4_7_3 0 0.02p
Rac4_7_4 nac4_7_3 nac4_7_4 169000.0
Cac4_7_4 nac4_7_4 0 0.02p
Rac4_7_5 nac4_7_4 a 169000.0
Rac4_8_0 ac4in nac4_8_0 169000.0
Cac4_8_0 nac4_8_0 0 0.02p
Rac4_8_1 nac4_8_0 nac4_8_1 169000.0
Cac4_8_1 nac4_8_1 0 0.02p
Rac4_8_2 nac4_8_1 nac4_8_2 169000.0
Cac4_8_2 nac4_8_2 0 0.02p
Rac4_8_3 nac4_8_2 nac4_8_3 169000.0
Cac4_8_3 nac4_8_3 0 0.02p
Rac4_8_4 nac4_8_3 nac4_8_4 169000.0
Cac4_8_4 nac4_8_4 0 0.02p
Rac4_8_5 nac4_8_4 a 169000.0
Rac4_9_0 ac4in nac4_9_0 169000.0
Cac4_9_0 nac4_9_0 0 0.02p
Rac4_9_1 nac4_9_0 nac4_9_1 169000.0
Cac4_9_1 nac4_9_1 0 0.02p
Rac4_9_2 nac4_9_1 nac4_9_2 169000.0
Cac4_9_2 nac4_9_2 0 0.02p
Rac4_9_3 nac4_9_2 nac4_9_3 169000.0
Cac4_9_3 nac4_9_3 0 0.02p
Rac4_9_4 nac4_9_3 nac4_9_4 169000.0
Cac4_9_4 nac4_9_4 0 0.02p
Rac4_9_5 nac4_9_4 a 169000.0
Rac4_10_0 ac4in nac4_10_0 169000.0
Cac4_10_0 nac4_10_0 0 0.02p
Rac4_10_1 nac4_10_0 nac4_10_1 169000.0
Cac4_10_1 nac4_10_1 0 0.02p
Rac4_10_2 nac4_10_1 nac4_10_2 169000.0
Cac4_10_2 nac4_10_2 0 0.02p
Rac4_10_3 nac4_10_2 nac4_10_3 169000.0
Cac4_10_3 nac4_10_3 0 0.02p
Rac4_10_4 nac4_10_3 nac4_10_4 169000.0
Cac4_10_4 nac4_10_4 0 0.02p
Rac4_10_5 nac4_10_4 a 169000.0
Rac4_11_0 ac4in nac4_11_0 169000.0
Cac4_11_0 nac4_11_0 0 0.02p
Rac4_11_1 nac4_11_0 nac4_11_1 169000.0
Cac4_11_1 nac4_11_1 0 0.02p
Rac4_11_2 nac4_11_1 nac4_11_2 169000.0
Cac4_11_2 nac4_11_2 0 0.02p
Rac4_11_3 nac4_11_2 nac4_11_3 169000.0
Cac4_11_3 nac4_11_3 0 0.02p
Rac4_11_4 nac4_11_3 nac4_11_4 169000.0
Cac4_11_4 nac4_11_4 0 0.02p
Rac4_11_5 nac4_11_4 a 169000.0
Rac4_12_0 ac4in nac4_12_0 169000.0
Cac4_12_0 nac4_12_0 0 0.02p
Rac4_12_1 nac4_12_0 nac4_12_1 169000.0
Cac4_12_1 nac4_12_1 0 0.02p
Rac4_12_2 nac4_12_1 nac4_12_2 169000.0
Cac4_12_2 nac4_12_2 0 0.02p
Rac4_12_3 nac4_12_2 nac4_12_3 169000.0
Cac4_12_3 nac4_12_3 0 0.02p
Rac4_12_4 nac4_12_3 nac4_12_4 169000.0
Cac4_12_4 nac4_12_4 0 0.02p
Rac4_12_5 nac4_12_4 a 169000.0
Rac4_13_0 ac4in nac4_13_0 169000.0
Cac4_13_0 nac4_13_0 0 0.02p
Rac4_13_1 nac4_13_0 nac4_13_1 169000.0
Cac4_13_1 nac4_13_1 0 0.02p
Rac4_13_2 nac4_13_1 nac4_13_2 169000.0
Cac4_13_2 nac4_13_2 0 0.02p
Rac4_13_3 nac4_13_2 nac4_13_3 169000.0
Cac4_13_3 nac4_13_3 0 0.02p
Rac4_13_4 nac4_13_3 nac4_13_4 169000.0
Cac4_13_4 nac4_13_4 0 0.02p
Rac4_13_5 nac4_13_4 a 169000.0
Rac4_14_0 ac4in nac4_14_0 169000.0
Cac4_14_0 nac4_14_0 0 0.02p
Rac4_14_1 nac4_14_0 nac4_14_1 169000.0
Cac4_14_1 nac4_14_1 0 0.02p
Rac4_14_2 nac4_14_1 nac4_14_2 169000.0
Cac4_14_2 nac4_14_2 0 0.02p
Rac4_14_3 nac4_14_2 nac4_14_3 169000.0
Cac4_14_3 nac4_14_3 0 0.02p
Rac4_14_4 nac4_14_3 nac4_14_4 169000.0
Cac4_14_4 nac4_14_4 0 0.02p
Rac4_14_5 nac4_14_4 a 169000.0
Rac4_15_0 ac4in nac4_15_0 169000.0
Cac4_15_0 nac4_15_0 0 0.02p
Rac4_15_1 nac4_15_0 nac4_15_1 169000.0
Cac4_15_1 nac4_15_1 0 0.02p
Rac4_15_2 nac4_15_1 nac4_15_2 169000.0
Cac4_15_2 nac4_15_2 0 0.02p
Rac4_15_3 nac4_15_2 nac4_15_3 169000.0
Cac4_15_3 nac4_15_3 0 0.02p
Rac4_15_4 nac4_15_3 nac4_15_4 169000.0
Cac4_15_4 nac4_15_4 0 0.02p
Rac4_15_5 nac4_15_4 a 169000.0
Rac4_16_0 ac4in nac4_16_0 169000.0
Cac4_16_0 nac4_16_0 0 0.02p
Rac4_16_1 nac4_16_0 nac4_16_1 169000.0
Cac4_16_1 nac4_16_1 0 0.02p
Rac4_16_2 nac4_16_1 nac4_16_2 169000.0
Cac4_16_2 nac4_16_2 0 0.02p
Rac4_16_3 nac4_16_2 nac4_16_3 169000.0
Cac4_16_3 nac4_16_3 0 0.02p
Rac4_16_4 nac4_16_3 nac4_16_4 169000.0
Cac4_16_4 nac4_16_4 0 0.02p
Rac4_16_5 nac4_16_4 a 169000.0
Rac4_17_0 ac4in nac4_17_0 169000.0
Cac4_17_0 nac4_17_0 0 0.02p
Rac4_17_1 nac4_17_0 nac4_17_1 169000.0
Cac4_17_1 nac4_17_1 0 0.02p
Rac4_17_2 nac4_17_1 nac4_17_2 169000.0
Cac4_17_2 nac4_17_2 0 0.02p
Rac4_17_3 nac4_17_2 nac4_17_3 169000.0
Cac4_17_3 nac4_17_3 0 0.02p
Rac4_17_4 nac4_17_3 nac4_17_4 169000.0
Cac4_17_4 nac4_17_4 0 0.02p
Rac4_17_5 nac4_17_4 a 169000.0
Rac4_18_0 ac4in nac4_18_0 169000.0
Cac4_18_0 nac4_18_0 0 0.02p
Rac4_18_1 nac4_18_0 nac4_18_1 169000.0
Cac4_18_1 nac4_18_1 0 0.02p
Rac4_18_2 nac4_18_1 nac4_18_2 169000.0
Cac4_18_2 nac4_18_2 0 0.02p
Rac4_18_3 nac4_18_2 nac4_18_3 169000.0
Cac4_18_3 nac4_18_3 0 0.02p
Rac4_18_4 nac4_18_3 nac4_18_4 169000.0
Cac4_18_4 nac4_18_4 0 0.02p
Rac4_18_5 nac4_18_4 a 169000.0
Rac4_19_0 ac4in nac4_19_0 169000.0
Cac4_19_0 nac4_19_0 0 0.02p
Rac4_19_1 nac4_19_0 nac4_19_1 169000.0
Cac4_19_1 nac4_19_1 0 0.02p
Rac4_19_2 nac4_19_1 nac4_19_2 169000.0
Cac4_19_2 nac4_19_2 0 0.02p
Rac4_19_3 nac4_19_2 nac4_19_3 169000.0
Cac4_19_3 nac4_19_3 0 0.02p
Rac4_19_4 nac4_19_3 nac4_19_4 169000.0
Cac4_19_4 nac4_19_4 0 0.02p
Rac4_19_5 nac4_19_4 a 169000.0
Rac4_20_0 ac4in nac4_20_0 169000.0
Cac4_20_0 nac4_20_0 0 0.02p
Rac4_20_1 nac4_20_0 nac4_20_1 169000.0
Cac4_20_1 nac4_20_1 0 0.02p
Rac4_20_2 nac4_20_1 nac4_20_2 169000.0
Cac4_20_2 nac4_20_2 0 0.02p
Rac4_20_3 nac4_20_2 nac4_20_3 169000.0
Cac4_20_3 nac4_20_3 0 0.02p
Rac4_20_4 nac4_20_3 nac4_20_4 169000.0
Cac4_20_4 nac4_20_4 0 0.02p
Rac4_20_5 nac4_20_4 a 169000.0
Rac4_21_0 ac4in nac4_21_0 169000.0
Cac4_21_0 nac4_21_0 0 0.02p
Rac4_21_1 nac4_21_0 nac4_21_1 169000.0
Cac4_21_1 nac4_21_1 0 0.02p
Rac4_21_2 nac4_21_1 nac4_21_2 169000.0
Cac4_21_2 nac4_21_2 0 0.02p
Rac4_21_3 nac4_21_2 nac4_21_3 169000.0
Cac4_21_3 nac4_21_3 0 0.02p
Rac4_21_4 nac4_21_3 nac4_21_4 169000.0
Cac4_21_4 nac4_21_4 0 0.02p
Rac4_21_5 nac4_21_4 a 169000.0
Rac4_22_0 ac4in nac4_22_0 169000.0
Cac4_22_0 nac4_22_0 0 0.02p
Rac4_22_1 nac4_22_0 nac4_22_1 169000.0
Cac4_22_1 nac4_22_1 0 0.02p
Rac4_22_2 nac4_22_1 nac4_22_2 169000.0
Cac4_22_2 nac4_22_2 0 0.02p
Rac4_22_3 nac4_22_2 nac4_22_3 169000.0
Cac4_22_3 nac4_22_3 0 0.02p
Rac4_22_4 nac4_22_3 nac4_22_4 169000.0
Cac4_22_4 nac4_22_4 0 0.02p
Rac4_22_5 nac4_22_4 a 169000.0
Rac4_23_0 ac4in nac4_23_0 169000.0
Cac4_23_0 nac4_23_0 0 0.02p
Rac4_23_1 nac4_23_0 nac4_23_1 169000.0
Cac4_23_1 nac4_23_1 0 0.02p
Rac4_23_2 nac4_23_1 nac4_23_2 169000.0
Cac4_23_2 nac4_23_2 0 0.02p
Rac4_23_3 nac4_23_2 nac4_23_3 169000.0
Cac4_23_3 nac4_23_3 0 0.02p
Rac4_23_4 nac4_23_3 nac4_23_4 169000.0
Cac4_23_4 nac4_23_4 0 0.02p
Rac4_23_5 nac4_23_4 a 169000.0
Vac5 ac5in 0 DC 0 AC 0.5
Rac5_0_0 ac5in nac5_0_0 169000.0
Cac5_0_0 nac5_0_0 0 0.02p
Rac5_0_1 nac5_0_0 nac5_0_1 169000.0
Cac5_0_1 nac5_0_1 0 0.02p
Rac5_0_2 nac5_0_1 nac5_0_2 169000.0
Cac5_0_2 nac5_0_2 0 0.02p
Rac5_0_3 nac5_0_2 nac5_0_3 169000.0
Cac5_0_3 nac5_0_3 0 0.02p
Rac5_0_4 nac5_0_3 nac5_0_4 169000.0
Cac5_0_4 nac5_0_4 0 0.02p
Rac5_0_5 nac5_0_4 a 169000.0
Rac5_1_0 ac5in nac5_1_0 169000.0
Cac5_1_0 nac5_1_0 0 0.02p
Rac5_1_1 nac5_1_0 nac5_1_1 169000.0
Cac5_1_1 nac5_1_1 0 0.02p
Rac5_1_2 nac5_1_1 nac5_1_2 169000.0
Cac5_1_2 nac5_1_2 0 0.02p
Rac5_1_3 nac5_1_2 nac5_1_3 169000.0
Cac5_1_3 nac5_1_3 0 0.02p
Rac5_1_4 nac5_1_3 nac5_1_4 169000.0
Cac5_1_4 nac5_1_4 0 0.02p
Rac5_1_5 nac5_1_4 a 169000.0
Rac5_2_0 ac5in nac5_2_0 169000.0
Cac5_2_0 nac5_2_0 0 0.02p
Rac5_2_1 nac5_2_0 nac5_2_1 169000.0
Cac5_2_1 nac5_2_1 0 0.02p
Rac5_2_2 nac5_2_1 nac5_2_2 169000.0
Cac5_2_2 nac5_2_2 0 0.02p
Rac5_2_3 nac5_2_2 nac5_2_3 169000.0
Cac5_2_3 nac5_2_3 0 0.02p
Rac5_2_4 nac5_2_3 nac5_2_4 169000.0
Cac5_2_4 nac5_2_4 0 0.02p
Rac5_2_5 nac5_2_4 a 169000.0
Rac5_3_0 ac5in nac5_3_0 169000.0
Cac5_3_0 nac5_3_0 0 0.02p
Rac5_3_1 nac5_3_0 nac5_3_1 169000.0
Cac5_3_1 nac5_3_1 0 0.02p
Rac5_3_2 nac5_3_1 nac5_3_2 169000.0
Cac5_3_2 nac5_3_2 0 0.02p
Rac5_3_3 nac5_3_2 nac5_3_3 169000.0
Cac5_3_3 nac5_3_3 0 0.02p
Rac5_3_4 nac5_3_3 nac5_3_4 169000.0
Cac5_3_4 nac5_3_4 0 0.02p
Rac5_3_5 nac5_3_4 a 169000.0
Rac5_4_0 ac5in nac5_4_0 169000.0
Cac5_4_0 nac5_4_0 0 0.02p
Rac5_4_1 nac5_4_0 nac5_4_1 169000.0
Cac5_4_1 nac5_4_1 0 0.02p
Rac5_4_2 nac5_4_1 nac5_4_2 169000.0
Cac5_4_2 nac5_4_2 0 0.02p
Rac5_4_3 nac5_4_2 nac5_4_3 169000.0
Cac5_4_3 nac5_4_3 0 0.02p
Rac5_4_4 nac5_4_3 nac5_4_4 169000.0
Cac5_4_4 nac5_4_4 0 0.02p
Rac5_4_5 nac5_4_4 a 169000.0
Rac5_5_0 ac5in nac5_5_0 169000.0
Cac5_5_0 nac5_5_0 0 0.02p
Rac5_5_1 nac5_5_0 nac5_5_1 169000.0
Cac5_5_1 nac5_5_1 0 0.02p
Rac5_5_2 nac5_5_1 nac5_5_2 169000.0
Cac5_5_2 nac5_5_2 0 0.02p
Rac5_5_3 nac5_5_2 nac5_5_3 169000.0
Cac5_5_3 nac5_5_3 0 0.02p
Rac5_5_4 nac5_5_3 nac5_5_4 169000.0
Cac5_5_4 nac5_5_4 0 0.02p
Rac5_5_5 nac5_5_4 a 169000.0
Rac5_6_0 ac5in nac5_6_0 169000.0
Cac5_6_0 nac5_6_0 0 0.02p
Rac5_6_1 nac5_6_0 nac5_6_1 169000.0
Cac5_6_1 nac5_6_1 0 0.02p
Rac5_6_2 nac5_6_1 nac5_6_2 169000.0
Cac5_6_2 nac5_6_2 0 0.02p
Rac5_6_3 nac5_6_2 nac5_6_3 169000.0
Cac5_6_3 nac5_6_3 0 0.02p
Rac5_6_4 nac5_6_3 nac5_6_4 169000.0
Cac5_6_4 nac5_6_4 0 0.02p
Rac5_6_5 nac5_6_4 a 169000.0
Rac5_7_0 ac5in nac5_7_0 169000.0
Cac5_7_0 nac5_7_0 0 0.02p
Rac5_7_1 nac5_7_0 nac5_7_1 169000.0
Cac5_7_1 nac5_7_1 0 0.02p
Rac5_7_2 nac5_7_1 nac5_7_2 169000.0
Cac5_7_2 nac5_7_2 0 0.02p
Rac5_7_3 nac5_7_2 nac5_7_3 169000.0
Cac5_7_3 nac5_7_3 0 0.02p
Rac5_7_4 nac5_7_3 nac5_7_4 169000.0
Cac5_7_4 nac5_7_4 0 0.02p
Rac5_7_5 nac5_7_4 a 169000.0
Rac5_8_0 ac5in nac5_8_0 169000.0
Cac5_8_0 nac5_8_0 0 0.02p
Rac5_8_1 nac5_8_0 nac5_8_1 169000.0
Cac5_8_1 nac5_8_1 0 0.02p
Rac5_8_2 nac5_8_1 nac5_8_2 169000.0
Cac5_8_2 nac5_8_2 0 0.02p
Rac5_8_3 nac5_8_2 nac5_8_3 169000.0
Cac5_8_3 nac5_8_3 0 0.02p
Rac5_8_4 nac5_8_3 nac5_8_4 169000.0
Cac5_8_4 nac5_8_4 0 0.02p
Rac5_8_5 nac5_8_4 a 169000.0
Rac5_9_0 ac5in nac5_9_0 169000.0
Cac5_9_0 nac5_9_0 0 0.02p
Rac5_9_1 nac5_9_0 nac5_9_1 169000.0
Cac5_9_1 nac5_9_1 0 0.02p
Rac5_9_2 nac5_9_1 nac5_9_2 169000.0
Cac5_9_2 nac5_9_2 0 0.02p
Rac5_9_3 nac5_9_2 nac5_9_3 169000.0
Cac5_9_3 nac5_9_3 0 0.02p
Rac5_9_4 nac5_9_3 nac5_9_4 169000.0
Cac5_9_4 nac5_9_4 0 0.02p
Rac5_9_5 nac5_9_4 a 169000.0
Rac5_10_0 ac5in nac5_10_0 169000.0
Cac5_10_0 nac5_10_0 0 0.02p
Rac5_10_1 nac5_10_0 nac5_10_1 169000.0
Cac5_10_1 nac5_10_1 0 0.02p
Rac5_10_2 nac5_10_1 nac5_10_2 169000.0
Cac5_10_2 nac5_10_2 0 0.02p
Rac5_10_3 nac5_10_2 nac5_10_3 169000.0
Cac5_10_3 nac5_10_3 0 0.02p
Rac5_10_4 nac5_10_3 nac5_10_4 169000.0
Cac5_10_4 nac5_10_4 0 0.02p
Rac5_10_5 nac5_10_4 a 169000.0
Rac5_11_0 ac5in nac5_11_0 169000.0
Cac5_11_0 nac5_11_0 0 0.02p
Rac5_11_1 nac5_11_0 nac5_11_1 169000.0
Cac5_11_1 nac5_11_1 0 0.02p
Rac5_11_2 nac5_11_1 nac5_11_2 169000.0
Cac5_11_2 nac5_11_2 0 0.02p
Rac5_11_3 nac5_11_2 nac5_11_3 169000.0
Cac5_11_3 nac5_11_3 0 0.02p
Rac5_11_4 nac5_11_3 nac5_11_4 169000.0
Cac5_11_4 nac5_11_4 0 0.02p
Rac5_11_5 nac5_11_4 a 169000.0
Rac5_12_0 ac5in nac5_12_0 169000.0
Cac5_12_0 nac5_12_0 0 0.02p
Rac5_12_1 nac5_12_0 nac5_12_1 169000.0
Cac5_12_1 nac5_12_1 0 0.02p
Rac5_12_2 nac5_12_1 nac5_12_2 169000.0
Cac5_12_2 nac5_12_2 0 0.02p
Rac5_12_3 nac5_12_2 nac5_12_3 169000.0
Cac5_12_3 nac5_12_3 0 0.02p
Rac5_12_4 nac5_12_3 nac5_12_4 169000.0
Cac5_12_4 nac5_12_4 0 0.02p
Rac5_12_5 nac5_12_4 a 169000.0
Rac5_13_0 ac5in nac5_13_0 169000.0
Cac5_13_0 nac5_13_0 0 0.02p
Rac5_13_1 nac5_13_0 nac5_13_1 169000.0
Cac5_13_1 nac5_13_1 0 0.02p
Rac5_13_2 nac5_13_1 nac5_13_2 169000.0
Cac5_13_2 nac5_13_2 0 0.02p
Rac5_13_3 nac5_13_2 nac5_13_3 169000.0
Cac5_13_3 nac5_13_3 0 0.02p
Rac5_13_4 nac5_13_3 nac5_13_4 169000.0
Cac5_13_4 nac5_13_4 0 0.02p
Rac5_13_5 nac5_13_4 a 169000.0
Rac5_14_0 ac5in nac5_14_0 169000.0
Cac5_14_0 nac5_14_0 0 0.02p
Rac5_14_1 nac5_14_0 nac5_14_1 169000.0
Cac5_14_1 nac5_14_1 0 0.02p
Rac5_14_2 nac5_14_1 nac5_14_2 169000.0
Cac5_14_2 nac5_14_2 0 0.02p
Rac5_14_3 nac5_14_2 nac5_14_3 169000.0
Cac5_14_3 nac5_14_3 0 0.02p
Rac5_14_4 nac5_14_3 nac5_14_4 169000.0
Cac5_14_4 nac5_14_4 0 0.02p
Rac5_14_5 nac5_14_4 a 169000.0
Rac5_15_0 ac5in nac5_15_0 169000.0
Cac5_15_0 nac5_15_0 0 0.02p
Rac5_15_1 nac5_15_0 nac5_15_1 169000.0
Cac5_15_1 nac5_15_1 0 0.02p
Rac5_15_2 nac5_15_1 nac5_15_2 169000.0
Cac5_15_2 nac5_15_2 0 0.02p
Rac5_15_3 nac5_15_2 nac5_15_3 169000.0
Cac5_15_3 nac5_15_3 0 0.02p
Rac5_15_4 nac5_15_3 nac5_15_4 169000.0
Cac5_15_4 nac5_15_4 0 0.02p
Rac5_15_5 nac5_15_4 a 169000.0
Rac5_16_0 ac5in nac5_16_0 169000.0
Cac5_16_0 nac5_16_0 0 0.02p
Rac5_16_1 nac5_16_0 nac5_16_1 169000.0
Cac5_16_1 nac5_16_1 0 0.02p
Rac5_16_2 nac5_16_1 nac5_16_2 169000.0
Cac5_16_2 nac5_16_2 0 0.02p
Rac5_16_3 nac5_16_2 nac5_16_3 169000.0
Cac5_16_3 nac5_16_3 0 0.02p
Rac5_16_4 nac5_16_3 nac5_16_4 169000.0
Cac5_16_4 nac5_16_4 0 0.02p
Rac5_16_5 nac5_16_4 a 169000.0
Rac5_17_0 ac5in nac5_17_0 169000.0
Cac5_17_0 nac5_17_0 0 0.02p
Rac5_17_1 nac5_17_0 nac5_17_1 169000.0
Cac5_17_1 nac5_17_1 0 0.02p
Rac5_17_2 nac5_17_1 nac5_17_2 169000.0
Cac5_17_2 nac5_17_2 0 0.02p
Rac5_17_3 nac5_17_2 nac5_17_3 169000.0
Cac5_17_3 nac5_17_3 0 0.02p
Rac5_17_4 nac5_17_3 nac5_17_4 169000.0
Cac5_17_4 nac5_17_4 0 0.02p
Rac5_17_5 nac5_17_4 a 169000.0
Rac5_18_0 ac5in nac5_18_0 169000.0
Cac5_18_0 nac5_18_0 0 0.02p
Rac5_18_1 nac5_18_0 nac5_18_1 169000.0
Cac5_18_1 nac5_18_1 0 0.02p
Rac5_18_2 nac5_18_1 nac5_18_2 169000.0
Cac5_18_2 nac5_18_2 0 0.02p
Rac5_18_3 nac5_18_2 nac5_18_3 169000.0
Cac5_18_3 nac5_18_3 0 0.02p
Rac5_18_4 nac5_18_3 nac5_18_4 169000.0
Cac5_18_4 nac5_18_4 0 0.02p
Rac5_18_5 nac5_18_4 a 169000.0
Rac5_19_0 ac5in nac5_19_0 169000.0
Cac5_19_0 nac5_19_0 0 0.02p
Rac5_19_1 nac5_19_0 nac5_19_1 169000.0
Cac5_19_1 nac5_19_1 0 0.02p
Rac5_19_2 nac5_19_1 nac5_19_2 169000.0
Cac5_19_2 nac5_19_2 0 0.02p
Rac5_19_3 nac5_19_2 nac5_19_3 169000.0
Cac5_19_3 nac5_19_3 0 0.02p
Rac5_19_4 nac5_19_3 nac5_19_4 169000.0
Cac5_19_4 nac5_19_4 0 0.02p
Rac5_19_5 nac5_19_4 a 169000.0
Rac5_20_0 ac5in nac5_20_0 169000.0
Cac5_20_0 nac5_20_0 0 0.02p
Rac5_20_1 nac5_20_0 nac5_20_1 169000.0
Cac5_20_1 nac5_20_1 0 0.02p
Rac5_20_2 nac5_20_1 nac5_20_2 169000.0
Cac5_20_2 nac5_20_2 0 0.02p
Rac5_20_3 nac5_20_2 nac5_20_3 169000.0
Cac5_20_3 nac5_20_3 0 0.02p
Rac5_20_4 nac5_20_3 nac5_20_4 169000.0
Cac5_20_4 nac5_20_4 0 0.02p
Rac5_20_5 nac5_20_4 a 169000.0
Rac5_21_0 ac5in nac5_21_0 169000.0
Cac5_21_0 nac5_21_0 0 0.02p
Rac5_21_1 nac5_21_0 nac5_21_1 169000.0
Cac5_21_1 nac5_21_1 0 0.02p
Rac5_21_2 nac5_21_1 nac5_21_2 169000.0
Cac5_21_2 nac5_21_2 0 0.02p
Rac5_21_3 nac5_21_2 nac5_21_3 169000.0
Cac5_21_3 nac5_21_3 0 0.02p
Rac5_21_4 nac5_21_3 nac5_21_4 169000.0
Cac5_21_4 nac5_21_4 0 0.02p
Rac5_21_5 nac5_21_4 a 169000.0
Rac5_22_0 ac5in nac5_22_0 169000.0
Cac5_22_0 nac5_22_0 0 0.02p
Rac5_22_1 nac5_22_0 nac5_22_1 169000.0
Cac5_22_1 nac5_22_1 0 0.02p
Rac5_22_2 nac5_22_1 nac5_22_2 169000.0
Cac5_22_2 nac5_22_2 0 0.02p
Rac5_22_3 nac5_22_2 nac5_22_3 169000.0
Cac5_22_3 nac5_22_3 0 0.02p
Rac5_22_4 nac5_22_3 nac5_22_4 169000.0
Cac5_22_4 nac5_22_4 0 0.02p
Rac5_22_5 nac5_22_4 a 169000.0
Rac5_23_0 ac5in nac5_23_0 169000.0
Cac5_23_0 nac5_23_0 0 0.02p
Rac5_23_1 nac5_23_0 nac5_23_1 169000.0
Cac5_23_1 nac5_23_1 0 0.02p
Rac5_23_2 nac5_23_1 nac5_23_2 169000.0
Cac5_23_2 nac5_23_2 0 0.02p
Rac5_23_3 nac5_23_2 nac5_23_3 169000.0
Cac5_23_3 nac5_23_3 0 0.02p
Rac5_23_4 nac5_23_3 nac5_23_4 169000.0
Cac5_23_4 nac5_23_4 0 0.02p
Rac5_23_5 nac5_23_4 a 169000.0
Vac6 ac6in 0 DC 0 AC 0.5
Rac6_0_0 ac6in nac6_0_0 169000.0
Cac6_0_0 nac6_0_0 0 0.02p
Rac6_0_1 nac6_0_0 nac6_0_1 169000.0
Cac6_0_1 nac6_0_1 0 0.02p
Rac6_0_2 nac6_0_1 nac6_0_2 169000.0
Cac6_0_2 nac6_0_2 0 0.02p
Rac6_0_3 nac6_0_2 nac6_0_3 169000.0
Cac6_0_3 nac6_0_3 0 0.02p
Rac6_0_4 nac6_0_3 nac6_0_4 169000.0
Cac6_0_4 nac6_0_4 0 0.02p
Rac6_0_5 nac6_0_4 a 169000.0
Rac6_1_0 ac6in nac6_1_0 169000.0
Cac6_1_0 nac6_1_0 0 0.02p
Rac6_1_1 nac6_1_0 nac6_1_1 169000.0
Cac6_1_1 nac6_1_1 0 0.02p
Rac6_1_2 nac6_1_1 nac6_1_2 169000.0
Cac6_1_2 nac6_1_2 0 0.02p
Rac6_1_3 nac6_1_2 nac6_1_3 169000.0
Cac6_1_3 nac6_1_3 0 0.02p
Rac6_1_4 nac6_1_3 nac6_1_4 169000.0
Cac6_1_4 nac6_1_4 0 0.02p
Rac6_1_5 nac6_1_4 a 169000.0
Rac6_2_0 ac6in nac6_2_0 169000.0
Cac6_2_0 nac6_2_0 0 0.02p
Rac6_2_1 nac6_2_0 nac6_2_1 169000.0
Cac6_2_1 nac6_2_1 0 0.02p
Rac6_2_2 nac6_2_1 nac6_2_2 169000.0
Cac6_2_2 nac6_2_2 0 0.02p
Rac6_2_3 nac6_2_2 nac6_2_3 169000.0
Cac6_2_3 nac6_2_3 0 0.02p
Rac6_2_4 nac6_2_3 nac6_2_4 169000.0
Cac6_2_4 nac6_2_4 0 0.02p
Rac6_2_5 nac6_2_4 a 169000.0
Rac6_3_0 ac6in nac6_3_0 169000.0
Cac6_3_0 nac6_3_0 0 0.02p
Rac6_3_1 nac6_3_0 nac6_3_1 169000.0
Cac6_3_1 nac6_3_1 0 0.02p
Rac6_3_2 nac6_3_1 nac6_3_2 169000.0
Cac6_3_2 nac6_3_2 0 0.02p
Rac6_3_3 nac6_3_2 nac6_3_3 169000.0
Cac6_3_3 nac6_3_3 0 0.02p
Rac6_3_4 nac6_3_3 nac6_3_4 169000.0
Cac6_3_4 nac6_3_4 0 0.02p
Rac6_3_5 nac6_3_4 a 169000.0
Rac6_4_0 ac6in nac6_4_0 169000.0
Cac6_4_0 nac6_4_0 0 0.02p
Rac6_4_1 nac6_4_0 nac6_4_1 169000.0
Cac6_4_1 nac6_4_1 0 0.02p
Rac6_4_2 nac6_4_1 nac6_4_2 169000.0
Cac6_4_2 nac6_4_2 0 0.02p
Rac6_4_3 nac6_4_2 nac6_4_3 169000.0
Cac6_4_3 nac6_4_3 0 0.02p
Rac6_4_4 nac6_4_3 nac6_4_4 169000.0
Cac6_4_4 nac6_4_4 0 0.02p
Rac6_4_5 nac6_4_4 a 169000.0
Rac6_5_0 ac6in nac6_5_0 169000.0
Cac6_5_0 nac6_5_0 0 0.02p
Rac6_5_1 nac6_5_0 nac6_5_1 169000.0
Cac6_5_1 nac6_5_1 0 0.02p
Rac6_5_2 nac6_5_1 nac6_5_2 169000.0
Cac6_5_2 nac6_5_2 0 0.02p
Rac6_5_3 nac6_5_2 nac6_5_3 169000.0
Cac6_5_3 nac6_5_3 0 0.02p
Rac6_5_4 nac6_5_3 nac6_5_4 169000.0
Cac6_5_4 nac6_5_4 0 0.02p
Rac6_5_5 nac6_5_4 a 169000.0
Rac6_6_0 ac6in nac6_6_0 169000.0
Cac6_6_0 nac6_6_0 0 0.02p
Rac6_6_1 nac6_6_0 nac6_6_1 169000.0
Cac6_6_1 nac6_6_1 0 0.02p
Rac6_6_2 nac6_6_1 nac6_6_2 169000.0
Cac6_6_2 nac6_6_2 0 0.02p
Rac6_6_3 nac6_6_2 nac6_6_3 169000.0
Cac6_6_3 nac6_6_3 0 0.02p
Rac6_6_4 nac6_6_3 nac6_6_4 169000.0
Cac6_6_4 nac6_6_4 0 0.02p
Rac6_6_5 nac6_6_4 a 169000.0
Rac6_7_0 ac6in nac6_7_0 169000.0
Cac6_7_0 nac6_7_0 0 0.02p
Rac6_7_1 nac6_7_0 nac6_7_1 169000.0
Cac6_7_1 nac6_7_1 0 0.02p
Rac6_7_2 nac6_7_1 nac6_7_2 169000.0
Cac6_7_2 nac6_7_2 0 0.02p
Rac6_7_3 nac6_7_2 nac6_7_3 169000.0
Cac6_7_3 nac6_7_3 0 0.02p
Rac6_7_4 nac6_7_3 nac6_7_4 169000.0
Cac6_7_4 nac6_7_4 0 0.02p
Rac6_7_5 nac6_7_4 a 169000.0
Rac6_8_0 ac6in nac6_8_0 169000.0
Cac6_8_0 nac6_8_0 0 0.02p
Rac6_8_1 nac6_8_0 nac6_8_1 169000.0
Cac6_8_1 nac6_8_1 0 0.02p
Rac6_8_2 nac6_8_1 nac6_8_2 169000.0
Cac6_8_2 nac6_8_2 0 0.02p
Rac6_8_3 nac6_8_2 nac6_8_3 169000.0
Cac6_8_3 nac6_8_3 0 0.02p
Rac6_8_4 nac6_8_3 nac6_8_4 169000.0
Cac6_8_4 nac6_8_4 0 0.02p
Rac6_8_5 nac6_8_4 a 169000.0
Rac6_9_0 ac6in nac6_9_0 169000.0
Cac6_9_0 nac6_9_0 0 0.02p
Rac6_9_1 nac6_9_0 nac6_9_1 169000.0
Cac6_9_1 nac6_9_1 0 0.02p
Rac6_9_2 nac6_9_1 nac6_9_2 169000.0
Cac6_9_2 nac6_9_2 0 0.02p
Rac6_9_3 nac6_9_2 nac6_9_3 169000.0
Cac6_9_3 nac6_9_3 0 0.02p
Rac6_9_4 nac6_9_3 nac6_9_4 169000.0
Cac6_9_4 nac6_9_4 0 0.02p
Rac6_9_5 nac6_9_4 a 169000.0
Rac6_10_0 ac6in nac6_10_0 169000.0
Cac6_10_0 nac6_10_0 0 0.02p
Rac6_10_1 nac6_10_0 nac6_10_1 169000.0
Cac6_10_1 nac6_10_1 0 0.02p
Rac6_10_2 nac6_10_1 nac6_10_2 169000.0
Cac6_10_2 nac6_10_2 0 0.02p
Rac6_10_3 nac6_10_2 nac6_10_3 169000.0
Cac6_10_3 nac6_10_3 0 0.02p
Rac6_10_4 nac6_10_3 nac6_10_4 169000.0
Cac6_10_4 nac6_10_4 0 0.02p
Rac6_10_5 nac6_10_4 a 169000.0
Rac6_11_0 ac6in nac6_11_0 169000.0
Cac6_11_0 nac6_11_0 0 0.02p
Rac6_11_1 nac6_11_0 nac6_11_1 169000.0
Cac6_11_1 nac6_11_1 0 0.02p
Rac6_11_2 nac6_11_1 nac6_11_2 169000.0
Cac6_11_2 nac6_11_2 0 0.02p
Rac6_11_3 nac6_11_2 nac6_11_3 169000.0
Cac6_11_3 nac6_11_3 0 0.02p
Rac6_11_4 nac6_11_3 nac6_11_4 169000.0
Cac6_11_4 nac6_11_4 0 0.02p
Rac6_11_5 nac6_11_4 a 169000.0
Rac6_12_0 ac6in nac6_12_0 169000.0
Cac6_12_0 nac6_12_0 0 0.02p
Rac6_12_1 nac6_12_0 nac6_12_1 169000.0
Cac6_12_1 nac6_12_1 0 0.02p
Rac6_12_2 nac6_12_1 nac6_12_2 169000.0
Cac6_12_2 nac6_12_2 0 0.02p
Rac6_12_3 nac6_12_2 nac6_12_3 169000.0
Cac6_12_3 nac6_12_3 0 0.02p
Rac6_12_4 nac6_12_3 nac6_12_4 169000.0
Cac6_12_4 nac6_12_4 0 0.02p
Rac6_12_5 nac6_12_4 a 169000.0
Rac6_13_0 ac6in nac6_13_0 169000.0
Cac6_13_0 nac6_13_0 0 0.02p
Rac6_13_1 nac6_13_0 nac6_13_1 169000.0
Cac6_13_1 nac6_13_1 0 0.02p
Rac6_13_2 nac6_13_1 nac6_13_2 169000.0
Cac6_13_2 nac6_13_2 0 0.02p
Rac6_13_3 nac6_13_2 nac6_13_3 169000.0
Cac6_13_3 nac6_13_3 0 0.02p
Rac6_13_4 nac6_13_3 nac6_13_4 169000.0
Cac6_13_4 nac6_13_4 0 0.02p
Rac6_13_5 nac6_13_4 a 169000.0
Rac6_14_0 ac6in nac6_14_0 169000.0
Cac6_14_0 nac6_14_0 0 0.02p
Rac6_14_1 nac6_14_0 nac6_14_1 169000.0
Cac6_14_1 nac6_14_1 0 0.02p
Rac6_14_2 nac6_14_1 nac6_14_2 169000.0
Cac6_14_2 nac6_14_2 0 0.02p
Rac6_14_3 nac6_14_2 nac6_14_3 169000.0
Cac6_14_3 nac6_14_3 0 0.02p
Rac6_14_4 nac6_14_3 nac6_14_4 169000.0
Cac6_14_4 nac6_14_4 0 0.02p
Rac6_14_5 nac6_14_4 a 169000.0
Rac6_15_0 ac6in nac6_15_0 169000.0
Cac6_15_0 nac6_15_0 0 0.02p
Rac6_15_1 nac6_15_0 nac6_15_1 169000.0
Cac6_15_1 nac6_15_1 0 0.02p
Rac6_15_2 nac6_15_1 nac6_15_2 169000.0
Cac6_15_2 nac6_15_2 0 0.02p
Rac6_15_3 nac6_15_2 nac6_15_3 169000.0
Cac6_15_3 nac6_15_3 0 0.02p
Rac6_15_4 nac6_15_3 nac6_15_4 169000.0
Cac6_15_4 nac6_15_4 0 0.02p
Rac6_15_5 nac6_15_4 a 169000.0
Rac6_16_0 ac6in nac6_16_0 169000.0
Cac6_16_0 nac6_16_0 0 0.02p
Rac6_16_1 nac6_16_0 nac6_16_1 169000.0
Cac6_16_1 nac6_16_1 0 0.02p
Rac6_16_2 nac6_16_1 nac6_16_2 169000.0
Cac6_16_2 nac6_16_2 0 0.02p
Rac6_16_3 nac6_16_2 nac6_16_3 169000.0
Cac6_16_3 nac6_16_3 0 0.02p
Rac6_16_4 nac6_16_3 nac6_16_4 169000.0
Cac6_16_4 nac6_16_4 0 0.02p
Rac6_16_5 nac6_16_4 a 169000.0
Rac6_17_0 ac6in nac6_17_0 169000.0
Cac6_17_0 nac6_17_0 0 0.02p
Rac6_17_1 nac6_17_0 nac6_17_1 169000.0
Cac6_17_1 nac6_17_1 0 0.02p
Rac6_17_2 nac6_17_1 nac6_17_2 169000.0
Cac6_17_2 nac6_17_2 0 0.02p
Rac6_17_3 nac6_17_2 nac6_17_3 169000.0
Cac6_17_3 nac6_17_3 0 0.02p
Rac6_17_4 nac6_17_3 nac6_17_4 169000.0
Cac6_17_4 nac6_17_4 0 0.02p
Rac6_17_5 nac6_17_4 a 169000.0
Rac6_18_0 ac6in nac6_18_0 169000.0
Cac6_18_0 nac6_18_0 0 0.02p
Rac6_18_1 nac6_18_0 nac6_18_1 169000.0
Cac6_18_1 nac6_18_1 0 0.02p
Rac6_18_2 nac6_18_1 nac6_18_2 169000.0
Cac6_18_2 nac6_18_2 0 0.02p
Rac6_18_3 nac6_18_2 nac6_18_3 169000.0
Cac6_18_3 nac6_18_3 0 0.02p
Rac6_18_4 nac6_18_3 nac6_18_4 169000.0
Cac6_18_4 nac6_18_4 0 0.02p
Rac6_18_5 nac6_18_4 a 169000.0
Rac6_19_0 ac6in nac6_19_0 169000.0
Cac6_19_0 nac6_19_0 0 0.02p
Rac6_19_1 nac6_19_0 nac6_19_1 169000.0
Cac6_19_1 nac6_19_1 0 0.02p
Rac6_19_2 nac6_19_1 nac6_19_2 169000.0
Cac6_19_2 nac6_19_2 0 0.02p
Rac6_19_3 nac6_19_2 nac6_19_3 169000.0
Cac6_19_3 nac6_19_3 0 0.02p
Rac6_19_4 nac6_19_3 nac6_19_4 169000.0
Cac6_19_4 nac6_19_4 0 0.02p
Rac6_19_5 nac6_19_4 a 169000.0
Rac6_20_0 ac6in nac6_20_0 169000.0
Cac6_20_0 nac6_20_0 0 0.02p
Rac6_20_1 nac6_20_0 nac6_20_1 169000.0
Cac6_20_1 nac6_20_1 0 0.02p
Rac6_20_2 nac6_20_1 nac6_20_2 169000.0
Cac6_20_2 nac6_20_2 0 0.02p
Rac6_20_3 nac6_20_2 nac6_20_3 169000.0
Cac6_20_3 nac6_20_3 0 0.02p
Rac6_20_4 nac6_20_3 nac6_20_4 169000.0
Cac6_20_4 nac6_20_4 0 0.02p
Rac6_20_5 nac6_20_4 a 169000.0
Rac6_21_0 ac6in nac6_21_0 169000.0
Cac6_21_0 nac6_21_0 0 0.02p
Rac6_21_1 nac6_21_0 nac6_21_1 169000.0
Cac6_21_1 nac6_21_1 0 0.02p
Rac6_21_2 nac6_21_1 nac6_21_2 169000.0
Cac6_21_2 nac6_21_2 0 0.02p
Rac6_21_3 nac6_21_2 nac6_21_3 169000.0
Cac6_21_3 nac6_21_3 0 0.02p
Rac6_21_4 nac6_21_3 nac6_21_4 169000.0
Cac6_21_4 nac6_21_4 0 0.02p
Rac6_21_5 nac6_21_4 a 169000.0
Rac6_22_0 ac6in nac6_22_0 169000.0
Cac6_22_0 nac6_22_0 0 0.02p
Rac6_22_1 nac6_22_0 nac6_22_1 169000.0
Cac6_22_1 nac6_22_1 0 0.02p
Rac6_22_2 nac6_22_1 nac6_22_2 169000.0
Cac6_22_2 nac6_22_2 0 0.02p
Rac6_22_3 nac6_22_2 nac6_22_3 169000.0
Cac6_22_3 nac6_22_3 0 0.02p
Rac6_22_4 nac6_22_3 nac6_22_4 169000.0
Cac6_22_4 nac6_22_4 0 0.02p
Rac6_22_5 nac6_22_4 a 169000.0
Rac6_23_0 ac6in nac6_23_0 169000.0
Cac6_23_0 nac6_23_0 0 0.02p
Rac6_23_1 nac6_23_0 nac6_23_1 169000.0
Cac6_23_1 nac6_23_1 0 0.02p
Rac6_23_2 nac6_23_1 nac6_23_2 169000.0
Cac6_23_2 nac6_23_2 0 0.02p
Rac6_23_3 nac6_23_2 nac6_23_3 169000.0
Cac6_23_3 nac6_23_3 0 0.02p
Rac6_23_4 nac6_23_3 nac6_23_4 169000.0
Cac6_23_4 nac6_23_4 0 0.02p
Rac6_23_5 nac6_23_4 a 169000.0
Vaf0 af0in 0 DC 0 AC 0.5
Raf0_0_0 af0in naf0_0_0 169000.0
Caf0_0_0 naf0_0_0 0 0.02p
Raf0_0_1 naf0_0_0 naf0_0_1 169000.0
Caf0_0_1 naf0_0_1 0 0.02p
Raf0_0_2 naf0_0_1 naf0_0_2 169000.0
Caf0_0_2 naf0_0_2 0 0.02p
Raf0_0_3 naf0_0_2 naf0_0_3 169000.0
Caf0_0_3 naf0_0_3 0 0.02p
Raf0_0_4 naf0_0_3 naf0_0_4 169000.0
Caf0_0_4 naf0_0_4 0 0.02p
Raf0_0_5 naf0_0_4 naf0_0_5 169000.0
Caf0_0_5 naf0_0_5 0 0.02p
Raf0_0_6 naf0_0_5 naf0_0_6 169000.0
Caf0_0_6 naf0_0_6 0 0.02p
Raf0_0_7 naf0_0_6 naf0_0_7 169000.0
Caf0_0_7 naf0_0_7 0 0.02p
Raf0_0_8 naf0_0_7 naf0_0_8 169000.0
Caf0_0_8 naf0_0_8 0 0.02p
Raf0_0_9 naf0_0_8 naf0_0_9 169000.0
Caf0_0_9 naf0_0_9 0 0.02p
Raf0_0_10 naf0_0_9 naf0_0_10 169000.0
Caf0_0_10 naf0_0_10 0 0.02p
Raf0_0_11 naf0_0_10 naf0_0_11 169000.0
Caf0_0_11 naf0_0_11 0 0.02p
Raf0_0_12 naf0_0_11 naf0_0_12 169000.0
Caf0_0_12 naf0_0_12 0 0.02p
Raf0_0_13 naf0_0_12 naf0_0_13 169000.0
Caf0_0_13 naf0_0_13 0 0.02p
Raf0_0_14 naf0_0_13 naf0_0_14 169000.0
Caf0_0_14 naf0_0_14 0 0.02p
Raf0_0_15 naf0_0_14 naf0_0_15 169000.0
Caf0_0_15 naf0_0_15 0 0.02p
Raf0_0_16 naf0_0_15 naf0_0_16 169000.0
Caf0_0_16 naf0_0_16 0 0.02p
Raf0_0_17 naf0_0_16 naf0_0_17 169000.0
Caf0_0_17 naf0_0_17 0 0.02p
Raf0_0_18 naf0_0_17 naf0_0_18 169000.0
Caf0_0_18 naf0_0_18 0 0.02p
Raf0_0_19 naf0_0_18 naf0_0_19 169000.0
Caf0_0_19 naf0_0_19 0 0.02p
Raf0_0_20 naf0_0_19 naf0_0_20 169000.0
Caf0_0_20 naf0_0_20 0 0.02p
Raf0_0_21 naf0_0_20 naf0_0_21 169000.0
Caf0_0_21 naf0_0_21 0 0.02p
Raf0_0_22 naf0_0_21 naf0_0_22 169000.0
Caf0_0_22 naf0_0_22 0 0.02p
Raf0_0_23 naf0_0_22 naf0_0_23 169000.0
Caf0_0_23 naf0_0_23 0 0.02p
Raf0_0_24 naf0_0_23 naf0_0_24 169000.0
Caf0_0_24 naf0_0_24 0 0.02p
Raf0_0_25 naf0_0_24 naf0_0_25 169000.0
Caf0_0_25 naf0_0_25 0 0.02p
Raf0_0_26 naf0_0_25 naf0_0_26 169000.0
Caf0_0_26 naf0_0_26 0 0.02p
Raf0_0_27 naf0_0_26 naf0_0_27 169000.0
Caf0_0_27 naf0_0_27 0 0.02p
Raf0_0_28 naf0_0_27 naf0_0_28 169000.0
Caf0_0_28 naf0_0_28 0 0.02p
Raf0_0_29 naf0_0_28 naf0_0_29 169000.0
Caf0_0_29 naf0_0_29 0 0.02p
Raf0_0_30 naf0_0_29 naf0_0_30 169000.0
Caf0_0_30 naf0_0_30 0 0.02p
Raf0_0_31 naf0_0_30 naf0_0_31 169000.0
Caf0_0_31 naf0_0_31 0 0.02p
Raf0_0_32 naf0_0_31 naf0_0_32 169000.0
Caf0_0_32 naf0_0_32 0 0.02p
Raf0_0_33 naf0_0_32 naf0_0_33 169000.0
Caf0_0_33 naf0_0_33 0 0.02p
Raf0_0_34 naf0_0_33 naf0_0_34 169000.0
Caf0_0_34 naf0_0_34 0 0.02p
Raf0_0_35 naf0_0_34 naf0_0_35 169000.0
Caf0_0_35 naf0_0_35 0 0.02p
Raf0_0_36 naf0_0_35 naf0_0_36 169000.0
Caf0_0_36 naf0_0_36 0 0.02p
Raf0_0_37 naf0_0_36 naf0_0_37 169000.0
Caf0_0_37 naf0_0_37 0 0.02p
Raf0_0_38 naf0_0_37 naf0_0_38 169000.0
Caf0_0_38 naf0_0_38 0 0.02p
Raf0_0_39 naf0_0_38 naf0_0_39 169000.0
Caf0_0_39 naf0_0_39 0 0.02p
Raf0_0_40 naf0_0_39 naf0_0_40 169000.0
Caf0_0_40 naf0_0_40 0 0.02p
Raf0_0_41 naf0_0_40 naf0_0_41 169000.0
Caf0_0_41 naf0_0_41 0 0.02p
Raf0_0_42 naf0_0_41 naf0_0_42 169000.0
Caf0_0_42 naf0_0_42 0 0.02p
Raf0_0_43 naf0_0_42 naf0_0_43 169000.0
Caf0_0_43 naf0_0_43 0 0.02p
Raf0_0_44 naf0_0_43 naf0_0_44 169000.0
Caf0_0_44 naf0_0_44 0 0.02p
Raf0_0_45 naf0_0_44 naf0_0_45 169000.0
Caf0_0_45 naf0_0_45 0 0.02p
Raf0_0_46 naf0_0_45 naf0_0_46 169000.0
Caf0_0_46 naf0_0_46 0 0.02p
Raf0_0_47 naf0_0_46 naf0_0_47 169000.0
Caf0_0_47 naf0_0_47 0 0.02p
Raf0_0_48 naf0_0_47 naf0_0_48 169000.0
Caf0_0_48 naf0_0_48 0 0.02p
Raf0_0_49 naf0_0_48 naf0_0_49 169000.0
Caf0_0_49 naf0_0_49 0 0.02p
Raf0_0_50 naf0_0_49 naf0_0_50 169000.0
Caf0_0_50 naf0_0_50 0 0.02p
Raf0_0_51 naf0_0_50 naf0_0_51 169000.0
Caf0_0_51 naf0_0_51 0 0.02p
Raf0_0_52 naf0_0_51 naf0_0_52 169000.0
Caf0_0_52 naf0_0_52 0 0.02p
Raf0_0_53 naf0_0_52 naf0_0_53 169000.0
Caf0_0_53 naf0_0_53 0 0.02p
Raf0_0_54 naf0_0_53 naf0_0_54 169000.0
Caf0_0_54 naf0_0_54 0 0.02p
Raf0_0_55 naf0_0_54 naf0_0_55 169000.0
Caf0_0_55 naf0_0_55 0 0.02p
Raf0_0_56 naf0_0_55 naf0_0_56 169000.0
Caf0_0_56 naf0_0_56 0 0.02p
Raf0_0_57 naf0_0_56 naf0_0_57 169000.0
Caf0_0_57 naf0_0_57 0 0.02p
Raf0_0_58 naf0_0_57 naf0_0_58 169000.0
Caf0_0_58 naf0_0_58 0 0.02p
Raf0_0_59 naf0_0_58 naf0_0_59 169000.0
Caf0_0_59 naf0_0_59 0 0.02p
Raf0_0_60 naf0_0_59 naf0_0_60 169000.0
Caf0_0_60 naf0_0_60 0 0.02p
Raf0_0_61 naf0_0_60 naf0_0_61 169000.0
Caf0_0_61 naf0_0_61 0 0.02p
Raf0_0_62 naf0_0_61 naf0_0_62 169000.0
Caf0_0_62 naf0_0_62 0 0.02p
Raf0_0_63 naf0_0_62 naf0_0_63 169000.0
Caf0_0_63 naf0_0_63 0 0.02p
Raf0_0_64 naf0_0_63 naf0_0_64 169000.0
Caf0_0_64 naf0_0_64 0 0.02p
Raf0_0_65 naf0_0_64 naf0_0_65 169000.0
Caf0_0_65 naf0_0_65 0 0.02p
Raf0_0_66 naf0_0_65 naf0_0_66 169000.0
Caf0_0_66 naf0_0_66 0 0.02p
Raf0_0_67 naf0_0_66 naf0_0_67 169000.0
Caf0_0_67 naf0_0_67 0 0.02p
Raf0_0_68 naf0_0_67 naf0_0_68 169000.0
Caf0_0_68 naf0_0_68 0 0.02p
Raf0_0_69 naf0_0_68 naf0_0_69 169000.0
Caf0_0_69 naf0_0_69 0 0.02p
Raf0_0_70 naf0_0_69 naf0_0_70 169000.0
Caf0_0_70 naf0_0_70 0 0.02p
Raf0_0_71 naf0_0_70 naf0_0_71 169000.0
Caf0_0_71 naf0_0_71 0 0.02p
Raf0_0_72 naf0_0_71 naf0_0_72 169000.0
Caf0_0_72 naf0_0_72 0 0.02p
Raf0_0_73 naf0_0_72 naf0_0_73 169000.0
Caf0_0_73 naf0_0_73 0 0.02p
Raf0_0_74 naf0_0_73 naf0_0_74 169000.0
Caf0_0_74 naf0_0_74 0 0.02p
Raf0_0_75 naf0_0_74 naf0_0_75 169000.0
Caf0_0_75 naf0_0_75 0 0.02p
Raf0_0_76 naf0_0_75 naf0_0_76 169000.0
Caf0_0_76 naf0_0_76 0 0.02p
Raf0_0_77 naf0_0_76 naf0_0_77 169000.0
Caf0_0_77 naf0_0_77 0 0.02p
Raf0_0_78 naf0_0_77 naf0_0_78 169000.0
Caf0_0_78 naf0_0_78 0 0.02p
Raf0_0_79 naf0_0_78 naf0_0_79 169000.0
Caf0_0_79 naf0_0_79 0 0.02p
Raf0_0_80 naf0_0_79 naf0_0_80 169000.0
Caf0_0_80 naf0_0_80 0 0.02p
Raf0_0_81 naf0_0_80 naf0_0_81 169000.0
Caf0_0_81 naf0_0_81 0 0.02p
Raf0_0_82 naf0_0_81 naf0_0_82 169000.0
Caf0_0_82 naf0_0_82 0 0.02p
Raf0_0_83 naf0_0_82 naf0_0_83 169000.0
Caf0_0_83 naf0_0_83 0 0.02p
Raf0_0_84 naf0_0_83 naf0_0_84 169000.0
Caf0_0_84 naf0_0_84 0 0.02p
Raf0_0_85 naf0_0_84 naf0_0_85 169000.0
Caf0_0_85 naf0_0_85 0 0.02p
Raf0_0_86 naf0_0_85 naf0_0_86 169000.0
Caf0_0_86 naf0_0_86 0 0.02p
Raf0_0_87 naf0_0_86 naf0_0_87 169000.0
Caf0_0_87 naf0_0_87 0 0.02p
Raf0_0_88 naf0_0_87 naf0_0_88 169000.0
Caf0_0_88 naf0_0_88 0 0.02p
Raf0_0_89 naf0_0_88 naf0_0_89 169000.0
Caf0_0_89 naf0_0_89 0 0.02p
Raf0_0_90 naf0_0_89 naf0_0_90 169000.0
Caf0_0_90 naf0_0_90 0 0.02p
Raf0_0_91 naf0_0_90 naf0_0_91 169000.0
Caf0_0_91 naf0_0_91 0 0.02p
Raf0_0_92 naf0_0_91 naf0_0_92 169000.0
Caf0_0_92 naf0_0_92 0 0.02p
Raf0_0_93 naf0_0_92 naf0_0_93 169000.0
Caf0_0_93 naf0_0_93 0 0.02p
Raf0_0_94 naf0_0_93 naf0_0_94 169000.0
Caf0_0_94 naf0_0_94 0 0.02p
Raf0_0_95 naf0_0_94 naf0_0_95 169000.0
Caf0_0_95 naf0_0_95 0 0.02p
Raf0_0_96 naf0_0_95 naf0_0_96 169000.0
Caf0_0_96 naf0_0_96 0 0.02p
Raf0_0_97 naf0_0_96 naf0_0_97 169000.0
Caf0_0_97 naf0_0_97 0 0.02p
Raf0_0_98 naf0_0_97 naf0_0_98 169000.0
Caf0_0_98 naf0_0_98 0 0.02p
Raf0_0_99 naf0_0_98 naf0_0_99 169000.0
Caf0_0_99 naf0_0_99 0 0.02p
Raf0_0_100 naf0_0_99 naf0_0_100 169000.0
Caf0_0_100 naf0_0_100 0 0.02p
Raf0_0_101 naf0_0_100 naf0_0_101 169000.0
Caf0_0_101 naf0_0_101 0 0.02p
Raf0_0_102 naf0_0_101 naf0_0_102 169000.0
Caf0_0_102 naf0_0_102 0 0.02p
Raf0_0_103 naf0_0_102 naf0_0_103 169000.0
Caf0_0_103 naf0_0_103 0 0.02p
Raf0_0_104 naf0_0_103 naf0_0_104 169000.0
Caf0_0_104 naf0_0_104 0 0.02p
Raf0_0_105 naf0_0_104 naf0_0_105 169000.0
Caf0_0_105 naf0_0_105 0 0.02p
Raf0_0_106 naf0_0_105 naf0_0_106 169000.0
Caf0_0_106 naf0_0_106 0 0.02p
Raf0_0_107 naf0_0_106 naf0_0_107 169000.0
Caf0_0_107 naf0_0_107 0 0.02p
Raf0_0_108 naf0_0_107 naf0_0_108 169000.0
Caf0_0_108 naf0_0_108 0 0.02p
Raf0_0_109 naf0_0_108 naf0_0_109 169000.0
Caf0_0_109 naf0_0_109 0 0.02p
Raf0_0_110 naf0_0_109 naf0_0_110 169000.0
Caf0_0_110 naf0_0_110 0 0.02p
Raf0_0_111 naf0_0_110 naf0_0_111 169000.0
Caf0_0_111 naf0_0_111 0 0.02p
Raf0_0_112 naf0_0_111 naf0_0_112 169000.0
Caf0_0_112 naf0_0_112 0 0.02p
Raf0_0_113 naf0_0_112 naf0_0_113 169000.0
Caf0_0_113 naf0_0_113 0 0.02p
Raf0_0_114 naf0_0_113 naf0_0_114 169000.0
Caf0_0_114 naf0_0_114 0 0.02p
Raf0_0_115 naf0_0_114 naf0_0_115 169000.0
Caf0_0_115 naf0_0_115 0 0.02p
Raf0_0_116 naf0_0_115 naf0_0_116 169000.0
Caf0_0_116 naf0_0_116 0 0.02p
Raf0_0_117 naf0_0_116 naf0_0_117 169000.0
Caf0_0_117 naf0_0_117 0 0.02p
Raf0_0_118 naf0_0_117 naf0_0_118 169000.0
Caf0_0_118 naf0_0_118 0 0.02p
Raf0_0_119 naf0_0_118 naf0_0_119 169000.0
Caf0_0_119 naf0_0_119 0 0.02p
Raf0_0_120 naf0_0_119 naf0_0_120 169000.0
Caf0_0_120 naf0_0_120 0 0.02p
Raf0_0_121 naf0_0_120 naf0_0_121 169000.0
Caf0_0_121 naf0_0_121 0 0.02p
Raf0_0_122 naf0_0_121 naf0_0_122 169000.0
Caf0_0_122 naf0_0_122 0 0.02p
Raf0_0_123 naf0_0_122 naf0_0_123 169000.0
Caf0_0_123 naf0_0_123 0 0.02p
Raf0_0_124 naf0_0_123 naf0_0_124 169000.0
Caf0_0_124 naf0_0_124 0 0.02p
Raf0_0_125 naf0_0_124 naf0_0_125 169000.0
Caf0_0_125 naf0_0_125 0 0.02p
Raf0_0_126 naf0_0_125 naf0_0_126 169000.0
Caf0_0_126 naf0_0_126 0 0.02p
Raf0_0_127 naf0_0_126 a 169000.0
Vaf1 af1in 0 DC 0 AC 0.5
Raf1_0_0 af1in naf1_0_0 169000.0
Caf1_0_0 naf1_0_0 0 0.02p
Raf1_0_1 naf1_0_0 naf1_0_1 169000.0
Caf1_0_1 naf1_0_1 0 0.02p
Raf1_0_2 naf1_0_1 naf1_0_2 169000.0
Caf1_0_2 naf1_0_2 0 0.02p
Raf1_0_3 naf1_0_2 naf1_0_3 169000.0
Caf1_0_3 naf1_0_3 0 0.02p
Raf1_0_4 naf1_0_3 naf1_0_4 169000.0
Caf1_0_4 naf1_0_4 0 0.02p
Raf1_0_5 naf1_0_4 naf1_0_5 169000.0
Caf1_0_5 naf1_0_5 0 0.02p
Raf1_0_6 naf1_0_5 naf1_0_6 169000.0
Caf1_0_6 naf1_0_6 0 0.02p
Raf1_0_7 naf1_0_6 naf1_0_7 169000.0
Caf1_0_7 naf1_0_7 0 0.02p
Raf1_0_8 naf1_0_7 naf1_0_8 169000.0
Caf1_0_8 naf1_0_8 0 0.02p
Raf1_0_9 naf1_0_8 naf1_0_9 169000.0
Caf1_0_9 naf1_0_9 0 0.02p
Raf1_0_10 naf1_0_9 naf1_0_10 169000.0
Caf1_0_10 naf1_0_10 0 0.02p
Raf1_0_11 naf1_0_10 naf1_0_11 169000.0
Caf1_0_11 naf1_0_11 0 0.02p
Raf1_0_12 naf1_0_11 naf1_0_12 169000.0
Caf1_0_12 naf1_0_12 0 0.02p
Raf1_0_13 naf1_0_12 naf1_0_13 169000.0
Caf1_0_13 naf1_0_13 0 0.02p
Raf1_0_14 naf1_0_13 naf1_0_14 169000.0
Caf1_0_14 naf1_0_14 0 0.02p
Raf1_0_15 naf1_0_14 naf1_0_15 169000.0
Caf1_0_15 naf1_0_15 0 0.02p
Raf1_0_16 naf1_0_15 naf1_0_16 169000.0
Caf1_0_16 naf1_0_16 0 0.02p
Raf1_0_17 naf1_0_16 naf1_0_17 169000.0
Caf1_0_17 naf1_0_17 0 0.02p
Raf1_0_18 naf1_0_17 naf1_0_18 169000.0
Caf1_0_18 naf1_0_18 0 0.02p
Raf1_0_19 naf1_0_18 naf1_0_19 169000.0
Caf1_0_19 naf1_0_19 0 0.02p
Raf1_0_20 naf1_0_19 naf1_0_20 169000.0
Caf1_0_20 naf1_0_20 0 0.02p
Raf1_0_21 naf1_0_20 naf1_0_21 169000.0
Caf1_0_21 naf1_0_21 0 0.02p
Raf1_0_22 naf1_0_21 naf1_0_22 169000.0
Caf1_0_22 naf1_0_22 0 0.02p
Raf1_0_23 naf1_0_22 naf1_0_23 169000.0
Caf1_0_23 naf1_0_23 0 0.02p
Raf1_0_24 naf1_0_23 naf1_0_24 169000.0
Caf1_0_24 naf1_0_24 0 0.02p
Raf1_0_25 naf1_0_24 naf1_0_25 169000.0
Caf1_0_25 naf1_0_25 0 0.02p
Raf1_0_26 naf1_0_25 naf1_0_26 169000.0
Caf1_0_26 naf1_0_26 0 0.02p
Raf1_0_27 naf1_0_26 naf1_0_27 169000.0
Caf1_0_27 naf1_0_27 0 0.02p
Raf1_0_28 naf1_0_27 naf1_0_28 169000.0
Caf1_0_28 naf1_0_28 0 0.02p
Raf1_0_29 naf1_0_28 naf1_0_29 169000.0
Caf1_0_29 naf1_0_29 0 0.02p
Raf1_0_30 naf1_0_29 naf1_0_30 169000.0
Caf1_0_30 naf1_0_30 0 0.02p
Raf1_0_31 naf1_0_30 naf1_0_31 169000.0
Caf1_0_31 naf1_0_31 0 0.02p
Raf1_0_32 naf1_0_31 naf1_0_32 169000.0
Caf1_0_32 naf1_0_32 0 0.02p
Raf1_0_33 naf1_0_32 naf1_0_33 169000.0
Caf1_0_33 naf1_0_33 0 0.02p
Raf1_0_34 naf1_0_33 naf1_0_34 169000.0
Caf1_0_34 naf1_0_34 0 0.02p
Raf1_0_35 naf1_0_34 naf1_0_35 169000.0
Caf1_0_35 naf1_0_35 0 0.02p
Raf1_0_36 naf1_0_35 naf1_0_36 169000.0
Caf1_0_36 naf1_0_36 0 0.02p
Raf1_0_37 naf1_0_36 naf1_0_37 169000.0
Caf1_0_37 naf1_0_37 0 0.02p
Raf1_0_38 naf1_0_37 naf1_0_38 169000.0
Caf1_0_38 naf1_0_38 0 0.02p
Raf1_0_39 naf1_0_38 naf1_0_39 169000.0
Caf1_0_39 naf1_0_39 0 0.02p
Raf1_0_40 naf1_0_39 naf1_0_40 169000.0
Caf1_0_40 naf1_0_40 0 0.02p
Raf1_0_41 naf1_0_40 naf1_0_41 169000.0
Caf1_0_41 naf1_0_41 0 0.02p
Raf1_0_42 naf1_0_41 naf1_0_42 169000.0
Caf1_0_42 naf1_0_42 0 0.02p
Raf1_0_43 naf1_0_42 naf1_0_43 169000.0
Caf1_0_43 naf1_0_43 0 0.02p
Raf1_0_44 naf1_0_43 naf1_0_44 169000.0
Caf1_0_44 naf1_0_44 0 0.02p
Raf1_0_45 naf1_0_44 naf1_0_45 169000.0
Caf1_0_45 naf1_0_45 0 0.02p
Raf1_0_46 naf1_0_45 naf1_0_46 169000.0
Caf1_0_46 naf1_0_46 0 0.02p
Raf1_0_47 naf1_0_46 naf1_0_47 169000.0
Caf1_0_47 naf1_0_47 0 0.02p
Raf1_0_48 naf1_0_47 naf1_0_48 169000.0
Caf1_0_48 naf1_0_48 0 0.02p
Raf1_0_49 naf1_0_48 naf1_0_49 169000.0
Caf1_0_49 naf1_0_49 0 0.02p
Raf1_0_50 naf1_0_49 naf1_0_50 169000.0
Caf1_0_50 naf1_0_50 0 0.02p
Raf1_0_51 naf1_0_50 naf1_0_51 169000.0
Caf1_0_51 naf1_0_51 0 0.02p
Raf1_0_52 naf1_0_51 naf1_0_52 169000.0
Caf1_0_52 naf1_0_52 0 0.02p
Raf1_0_53 naf1_0_52 naf1_0_53 169000.0
Caf1_0_53 naf1_0_53 0 0.02p
Raf1_0_54 naf1_0_53 naf1_0_54 169000.0
Caf1_0_54 naf1_0_54 0 0.02p
Raf1_0_55 naf1_0_54 naf1_0_55 169000.0
Caf1_0_55 naf1_0_55 0 0.02p
Raf1_0_56 naf1_0_55 naf1_0_56 169000.0
Caf1_0_56 naf1_0_56 0 0.02p
Raf1_0_57 naf1_0_56 naf1_0_57 169000.0
Caf1_0_57 naf1_0_57 0 0.02p
Raf1_0_58 naf1_0_57 naf1_0_58 169000.0
Caf1_0_58 naf1_0_58 0 0.02p
Raf1_0_59 naf1_0_58 naf1_0_59 169000.0
Caf1_0_59 naf1_0_59 0 0.02p
Raf1_0_60 naf1_0_59 naf1_0_60 169000.0
Caf1_0_60 naf1_0_60 0 0.02p
Raf1_0_61 naf1_0_60 naf1_0_61 169000.0
Caf1_0_61 naf1_0_61 0 0.02p
Raf1_0_62 naf1_0_61 naf1_0_62 169000.0
Caf1_0_62 naf1_0_62 0 0.02p
Raf1_0_63 naf1_0_62 a 169000.0
Vaf2 af2in 0 DC 0 AC 0.5
Raf2_0_0 af2in naf2_0_0 169000.0
Caf2_0_0 naf2_0_0 0 0.02p
Raf2_0_1 naf2_0_0 naf2_0_1 169000.0
Caf2_0_1 naf2_0_1 0 0.02p
Raf2_0_2 naf2_0_1 naf2_0_2 169000.0
Caf2_0_2 naf2_0_2 0 0.02p
Raf2_0_3 naf2_0_2 naf2_0_3 169000.0
Caf2_0_3 naf2_0_3 0 0.02p
Raf2_0_4 naf2_0_3 naf2_0_4 169000.0
Caf2_0_4 naf2_0_4 0 0.02p
Raf2_0_5 naf2_0_4 naf2_0_5 169000.0
Caf2_0_5 naf2_0_5 0 0.02p
Raf2_0_6 naf2_0_5 naf2_0_6 169000.0
Caf2_0_6 naf2_0_6 0 0.02p
Raf2_0_7 naf2_0_6 naf2_0_7 169000.0
Caf2_0_7 naf2_0_7 0 0.02p
Raf2_0_8 naf2_0_7 naf2_0_8 169000.0
Caf2_0_8 naf2_0_8 0 0.02p
Raf2_0_9 naf2_0_8 naf2_0_9 169000.0
Caf2_0_9 naf2_0_9 0 0.02p
Raf2_0_10 naf2_0_9 naf2_0_10 169000.0
Caf2_0_10 naf2_0_10 0 0.02p
Raf2_0_11 naf2_0_10 naf2_0_11 169000.0
Caf2_0_11 naf2_0_11 0 0.02p
Raf2_0_12 naf2_0_11 naf2_0_12 169000.0
Caf2_0_12 naf2_0_12 0 0.02p
Raf2_0_13 naf2_0_12 naf2_0_13 169000.0
Caf2_0_13 naf2_0_13 0 0.02p
Raf2_0_14 naf2_0_13 naf2_0_14 169000.0
Caf2_0_14 naf2_0_14 0 0.02p
Raf2_0_15 naf2_0_14 naf2_0_15 169000.0
Caf2_0_15 naf2_0_15 0 0.02p
Raf2_0_16 naf2_0_15 naf2_0_16 169000.0
Caf2_0_16 naf2_0_16 0 0.02p
Raf2_0_17 naf2_0_16 naf2_0_17 169000.0
Caf2_0_17 naf2_0_17 0 0.02p
Raf2_0_18 naf2_0_17 naf2_0_18 169000.0
Caf2_0_18 naf2_0_18 0 0.02p
Raf2_0_19 naf2_0_18 naf2_0_19 169000.0
Caf2_0_19 naf2_0_19 0 0.02p
Raf2_0_20 naf2_0_19 naf2_0_20 169000.0
Caf2_0_20 naf2_0_20 0 0.02p
Raf2_0_21 naf2_0_20 naf2_0_21 169000.0
Caf2_0_21 naf2_0_21 0 0.02p
Raf2_0_22 naf2_0_21 naf2_0_22 169000.0
Caf2_0_22 naf2_0_22 0 0.02p
Raf2_0_23 naf2_0_22 naf2_0_23 169000.0
Caf2_0_23 naf2_0_23 0 0.02p
Raf2_0_24 naf2_0_23 naf2_0_24 169000.0
Caf2_0_24 naf2_0_24 0 0.02p
Raf2_0_25 naf2_0_24 naf2_0_25 169000.0
Caf2_0_25 naf2_0_25 0 0.02p
Raf2_0_26 naf2_0_25 naf2_0_26 169000.0
Caf2_0_26 naf2_0_26 0 0.02p
Raf2_0_27 naf2_0_26 naf2_0_27 169000.0
Caf2_0_27 naf2_0_27 0 0.02p
Raf2_0_28 naf2_0_27 naf2_0_28 169000.0
Caf2_0_28 naf2_0_28 0 0.02p
Raf2_0_29 naf2_0_28 naf2_0_29 169000.0
Caf2_0_29 naf2_0_29 0 0.02p
Raf2_0_30 naf2_0_29 naf2_0_30 169000.0
Caf2_0_30 naf2_0_30 0 0.02p
Raf2_0_31 naf2_0_30 a 169000.0
Vaf3 af3in 0 DC 0 AC 0.5
Raf3_0_0 af3in naf3_0_0 169000.0
Caf3_0_0 naf3_0_0 0 0.02p
Raf3_0_1 naf3_0_0 naf3_0_1 169000.0
Caf3_0_1 naf3_0_1 0 0.02p
Raf3_0_2 naf3_0_1 naf3_0_2 169000.0
Caf3_0_2 naf3_0_2 0 0.02p
Raf3_0_3 naf3_0_2 naf3_0_3 169000.0
Caf3_0_3 naf3_0_3 0 0.02p
Raf3_0_4 naf3_0_3 naf3_0_4 169000.0
Caf3_0_4 naf3_0_4 0 0.02p
Raf3_0_5 naf3_0_4 naf3_0_5 169000.0
Caf3_0_5 naf3_0_5 0 0.02p
Raf3_0_6 naf3_0_5 naf3_0_6 169000.0
Caf3_0_6 naf3_0_6 0 0.02p
Raf3_0_7 naf3_0_6 naf3_0_7 169000.0
Caf3_0_7 naf3_0_7 0 0.02p
Raf3_0_8 naf3_0_7 naf3_0_8 169000.0
Caf3_0_8 naf3_0_8 0 0.02p
Raf3_0_9 naf3_0_8 naf3_0_9 169000.0
Caf3_0_9 naf3_0_9 0 0.02p
Raf3_0_10 naf3_0_9 naf3_0_10 169000.0
Caf3_0_10 naf3_0_10 0 0.02p
Raf3_0_11 naf3_0_10 naf3_0_11 169000.0
Caf3_0_11 naf3_0_11 0 0.02p
Raf3_0_12 naf3_0_11 naf3_0_12 169000.0
Caf3_0_12 naf3_0_12 0 0.02p
Raf3_0_13 naf3_0_12 naf3_0_13 169000.0
Caf3_0_13 naf3_0_13 0 0.02p
Raf3_0_14 naf3_0_13 naf3_0_14 169000.0
Caf3_0_14 naf3_0_14 0 0.02p
Raf3_0_15 naf3_0_14 a 169000.0
Vaf4 af4in 0 DC 0 AC 0.5
Raf4_0_0 af4in naf4_0_0 169000.0
Caf4_0_0 naf4_0_0 0 0.02p
Raf4_0_1 naf4_0_0 naf4_0_1 169000.0
Caf4_0_1 naf4_0_1 0 0.02p
Raf4_0_2 naf4_0_1 naf4_0_2 169000.0
Caf4_0_2 naf4_0_2 0 0.02p
Raf4_0_3 naf4_0_2 naf4_0_3 169000.0
Caf4_0_3 naf4_0_3 0 0.02p
Raf4_0_4 naf4_0_3 naf4_0_4 169000.0
Caf4_0_4 naf4_0_4 0 0.02p
Raf4_0_5 naf4_0_4 naf4_0_5 169000.0
Caf4_0_5 naf4_0_5 0 0.02p
Raf4_0_6 naf4_0_5 naf4_0_6 169000.0
Caf4_0_6 naf4_0_6 0 0.02p
Raf4_0_7 naf4_0_6 a 169000.0
Vaf5 af5in 0 DC 0 AC 0.5
Raf5_0_0 af5in naf5_0_0 169000.0
Caf5_0_0 naf5_0_0 0 0.02p
Raf5_0_1 naf5_0_0 naf5_0_1 169000.0
Caf5_0_1 naf5_0_1 0 0.02p
Raf5_0_2 naf5_0_1 naf5_0_2 169000.0
Caf5_0_2 naf5_0_2 0 0.02p
Raf5_0_3 naf5_0_2 naf5_0_3 169000.0
Caf5_0_3 naf5_0_3 0 0.02p
Raf5_0_4 naf5_0_3 naf5_0_4 169000.0
Caf5_0_4 naf5_0_4 0 0.02p
Raf5_0_5 naf5_0_4 naf5_0_5 169000.0
Caf5_0_5 naf5_0_5 0 0.02p
Raf5_0_6 naf5_0_5 naf5_0_6 169000.0
Caf5_0_6 naf5_0_6 0 0.02p
Raf5_0_7 naf5_0_6 a 169000.0
Raf5_1_0 af5in naf5_1_0 169000.0
Caf5_1_0 naf5_1_0 0 0.02p
Raf5_1_1 naf5_1_0 naf5_1_1 169000.0
Caf5_1_1 naf5_1_1 0 0.02p
Raf5_1_2 naf5_1_1 naf5_1_2 169000.0
Caf5_1_2 naf5_1_2 0 0.02p
Raf5_1_3 naf5_1_2 naf5_1_3 169000.0
Caf5_1_3 naf5_1_3 0 0.02p
Raf5_1_4 naf5_1_3 naf5_1_4 169000.0
Caf5_1_4 naf5_1_4 0 0.02p
Raf5_1_5 naf5_1_4 naf5_1_5 169000.0
Caf5_1_5 naf5_1_5 0 0.02p
Raf5_1_6 naf5_1_5 naf5_1_6 169000.0
Caf5_1_6 naf5_1_6 0 0.02p
Raf5_1_7 naf5_1_6 a 169000.0
Vaf6 af6in 0 DC 0 AC 0.5
Raf6_0_0 af6in naf6_0_0 169000.0
Caf6_0_0 naf6_0_0 0 0.02p
Raf6_0_1 naf6_0_0 naf6_0_1 169000.0
Caf6_0_1 naf6_0_1 0 0.02p
Raf6_0_2 naf6_0_1 naf6_0_2 169000.0
Caf6_0_2 naf6_0_2 0 0.02p
Raf6_0_3 naf6_0_2 naf6_0_3 169000.0
Caf6_0_3 naf6_0_3 0 0.02p
Raf6_0_4 naf6_0_3 naf6_0_4 169000.0
Caf6_0_4 naf6_0_4 0 0.02p
Raf6_0_5 naf6_0_4 a 169000.0
Raf6_1_0 af6in naf6_1_0 169000.0
Caf6_1_0 naf6_1_0 0 0.02p
Raf6_1_1 naf6_1_0 naf6_1_1 169000.0
Caf6_1_1 naf6_1_1 0 0.02p
Raf6_1_2 naf6_1_1 naf6_1_2 169000.0
Caf6_1_2 naf6_1_2 0 0.02p
Raf6_1_3 naf6_1_2 naf6_1_3 169000.0
Caf6_1_3 naf6_1_3 0 0.02p
Raf6_1_4 naf6_1_3 naf6_1_4 169000.0
Caf6_1_4 naf6_1_4 0 0.02p
Raf6_1_5 naf6_1_4 a 169000.0
Raf6_2_0 af6in naf6_2_0 169000.0
Caf6_2_0 naf6_2_0 0 0.02p
Raf6_2_1 naf6_2_0 naf6_2_1 169000.0
Caf6_2_1 naf6_2_1 0 0.02p
Raf6_2_2 naf6_2_1 naf6_2_2 169000.0
Caf6_2_2 naf6_2_2 0 0.02p
Raf6_2_3 naf6_2_2 naf6_2_3 169000.0
Caf6_2_3 naf6_2_3 0 0.02p
Raf6_2_4 naf6_2_3 naf6_2_4 169000.0
Caf6_2_4 naf6_2_4 0 0.02p
Raf6_2_5 naf6_2_4 a 169000.0
Vaf7 af7in 0 DC 0 AC 0.5
Raf7_0_0 af7in naf7_0_0 169000.0
Caf7_0_0 naf7_0_0 0 0.02p
Raf7_0_1 naf7_0_0 naf7_0_1 169000.0
Caf7_0_1 naf7_0_1 0 0.02p
Raf7_0_2 naf7_0_1 naf7_0_2 169000.0
Caf7_0_2 naf7_0_2 0 0.02p
Raf7_0_3 naf7_0_2 naf7_0_3 169000.0
Caf7_0_3 naf7_0_3 0 0.02p
Raf7_0_4 naf7_0_3 naf7_0_4 169000.0
Caf7_0_4 naf7_0_4 0 0.02p
Raf7_0_5 naf7_0_4 a 169000.0
Raf7_1_0 af7in naf7_1_0 169000.0
Caf7_1_0 naf7_1_0 0 0.02p
Raf7_1_1 naf7_1_0 naf7_1_1 169000.0
Caf7_1_1 naf7_1_1 0 0.02p
Raf7_1_2 naf7_1_1 naf7_1_2 169000.0
Caf7_1_2 naf7_1_2 0 0.02p
Raf7_1_3 naf7_1_2 naf7_1_3 169000.0
Caf7_1_3 naf7_1_3 0 0.02p
Raf7_1_4 naf7_1_3 naf7_1_4 169000.0
Caf7_1_4 naf7_1_4 0 0.02p
Raf7_1_5 naf7_1_4 a 169000.0
Raf7_2_0 af7in naf7_2_0 169000.0
Caf7_2_0 naf7_2_0 0 0.02p
Raf7_2_1 naf7_2_0 naf7_2_1 169000.0
Caf7_2_1 naf7_2_1 0 0.02p
Raf7_2_2 naf7_2_1 naf7_2_2 169000.0
Caf7_2_2 naf7_2_2 0 0.02p
Raf7_2_3 naf7_2_2 naf7_2_3 169000.0
Caf7_2_3 naf7_2_3 0 0.02p
Raf7_2_4 naf7_2_3 naf7_2_4 169000.0
Caf7_2_4 naf7_2_4 0 0.02p
Raf7_2_5 naf7_2_4 a 169000.0
Raf7_3_0 af7in naf7_3_0 169000.0
Caf7_3_0 naf7_3_0 0 0.02p
Raf7_3_1 naf7_3_0 naf7_3_1 169000.0
Caf7_3_1 naf7_3_1 0 0.02p
Raf7_3_2 naf7_3_1 naf7_3_2 169000.0
Caf7_3_2 naf7_3_2 0 0.02p
Raf7_3_3 naf7_3_2 naf7_3_3 169000.0
Caf7_3_3 naf7_3_3 0 0.02p
Raf7_3_4 naf7_3_3 naf7_3_4 169000.0
Caf7_3_4 naf7_3_4 0 0.02p
Raf7_3_5 naf7_3_4 a 169000.0
Raf7_4_0 af7in naf7_4_0 169000.0
Caf7_4_0 naf7_4_0 0 0.02p
Raf7_4_1 naf7_4_0 naf7_4_1 169000.0
Caf7_4_1 naf7_4_1 0 0.02p
Raf7_4_2 naf7_4_1 naf7_4_2 169000.0
Caf7_4_2 naf7_4_2 0 0.02p
Raf7_4_3 naf7_4_2 naf7_4_3 169000.0
Caf7_4_3 naf7_4_3 0 0.02p
Raf7_4_4 naf7_4_3 naf7_4_4 169000.0
Caf7_4_4 naf7_4_4 0 0.02p
Raf7_4_5 naf7_4_4 a 169000.0
Raf7_5_0 af7in naf7_5_0 169000.0
Caf7_5_0 naf7_5_0 0 0.02p
Raf7_5_1 naf7_5_0 naf7_5_1 169000.0
Caf7_5_1 naf7_5_1 0 0.02p
Raf7_5_2 naf7_5_1 naf7_5_2 169000.0
Caf7_5_2 naf7_5_2 0 0.02p
Raf7_5_3 naf7_5_2 naf7_5_3 169000.0
Caf7_5_3 naf7_5_3 0 0.02p
Raf7_5_4 naf7_5_3 naf7_5_4 169000.0
Caf7_5_4 naf7_5_4 0 0.02p
Raf7_5_5 naf7_5_4 a 169000.0
Vaf8 af8in 0 DC 0 AC 0.5
Raf8_0_0 af8in naf8_0_0 169000.0
Caf8_0_0 naf8_0_0 0 0.02p
Raf8_0_1 naf8_0_0 naf8_0_1 169000.0
Caf8_0_1 naf8_0_1 0 0.02p
Raf8_0_2 naf8_0_1 naf8_0_2 169000.0
Caf8_0_2 naf8_0_2 0 0.02p
Raf8_0_3 naf8_0_2 naf8_0_3 169000.0
Caf8_0_3 naf8_0_3 0 0.02p
Raf8_0_4 naf8_0_3 naf8_0_4 169000.0
Caf8_0_4 naf8_0_4 0 0.02p
Raf8_0_5 naf8_0_4 a 169000.0
Raf8_1_0 af8in naf8_1_0 169000.0
Caf8_1_0 naf8_1_0 0 0.02p
Raf8_1_1 naf8_1_0 naf8_1_1 169000.0
Caf8_1_1 naf8_1_1 0 0.02p
Raf8_1_2 naf8_1_1 naf8_1_2 169000.0
Caf8_1_2 naf8_1_2 0 0.02p
Raf8_1_3 naf8_1_2 naf8_1_3 169000.0
Caf8_1_3 naf8_1_3 0 0.02p
Raf8_1_4 naf8_1_3 naf8_1_4 169000.0
Caf8_1_4 naf8_1_4 0 0.02p
Raf8_1_5 naf8_1_4 a 169000.0
Raf8_2_0 af8in naf8_2_0 169000.0
Caf8_2_0 naf8_2_0 0 0.02p
Raf8_2_1 naf8_2_0 naf8_2_1 169000.0
Caf8_2_1 naf8_2_1 0 0.02p
Raf8_2_2 naf8_2_1 naf8_2_2 169000.0
Caf8_2_2 naf8_2_2 0 0.02p
Raf8_2_3 naf8_2_2 naf8_2_3 169000.0
Caf8_2_3 naf8_2_3 0 0.02p
Raf8_2_4 naf8_2_3 naf8_2_4 169000.0
Caf8_2_4 naf8_2_4 0 0.02p
Raf8_2_5 naf8_2_4 a 169000.0
Raf8_3_0 af8in naf8_3_0 169000.0
Caf8_3_0 naf8_3_0 0 0.02p
Raf8_3_1 naf8_3_0 naf8_3_1 169000.0
Caf8_3_1 naf8_3_1 0 0.02p
Raf8_3_2 naf8_3_1 naf8_3_2 169000.0
Caf8_3_2 naf8_3_2 0 0.02p
Raf8_3_3 naf8_3_2 naf8_3_3 169000.0
Caf8_3_3 naf8_3_3 0 0.02p
Raf8_3_4 naf8_3_3 naf8_3_4 169000.0
Caf8_3_4 naf8_3_4 0 0.02p
Raf8_3_5 naf8_3_4 a 169000.0
Raf8_4_0 af8in naf8_4_0 169000.0
Caf8_4_0 naf8_4_0 0 0.02p
Raf8_4_1 naf8_4_0 naf8_4_1 169000.0
Caf8_4_1 naf8_4_1 0 0.02p
Raf8_4_2 naf8_4_1 naf8_4_2 169000.0
Caf8_4_2 naf8_4_2 0 0.02p
Raf8_4_3 naf8_4_2 naf8_4_3 169000.0
Caf8_4_3 naf8_4_3 0 0.02p
Raf8_4_4 naf8_4_3 naf8_4_4 169000.0
Caf8_4_4 naf8_4_4 0 0.02p
Raf8_4_5 naf8_4_4 a 169000.0
Raf8_5_0 af8in naf8_5_0 169000.0
Caf8_5_0 naf8_5_0 0 0.02p
Raf8_5_1 naf8_5_0 naf8_5_1 169000.0
Caf8_5_1 naf8_5_1 0 0.02p
Raf8_5_2 naf8_5_1 naf8_5_2 169000.0
Caf8_5_2 naf8_5_2 0 0.02p
Raf8_5_3 naf8_5_2 naf8_5_3 169000.0
Caf8_5_3 naf8_5_3 0 0.02p
Raf8_5_4 naf8_5_3 naf8_5_4 169000.0
Caf8_5_4 naf8_5_4 0 0.02p
Raf8_5_5 naf8_5_4 a 169000.0
Raf8_6_0 af8in naf8_6_0 169000.0
Caf8_6_0 naf8_6_0 0 0.02p
Raf8_6_1 naf8_6_0 naf8_6_1 169000.0
Caf8_6_1 naf8_6_1 0 0.02p
Raf8_6_2 naf8_6_1 naf8_6_2 169000.0
Caf8_6_2 naf8_6_2 0 0.02p
Raf8_6_3 naf8_6_2 naf8_6_3 169000.0
Caf8_6_3 naf8_6_3 0 0.02p
Raf8_6_4 naf8_6_3 naf8_6_4 169000.0
Caf8_6_4 naf8_6_4 0 0.02p
Raf8_6_5 naf8_6_4 a 169000.0
Raf8_7_0 af8in naf8_7_0 169000.0
Caf8_7_0 naf8_7_0 0 0.02p
Raf8_7_1 naf8_7_0 naf8_7_1 169000.0
Caf8_7_1 naf8_7_1 0 0.02p
Raf8_7_2 naf8_7_1 naf8_7_2 169000.0
Caf8_7_2 naf8_7_2 0 0.02p
Raf8_7_3 naf8_7_2 naf8_7_3 169000.0
Caf8_7_3 naf8_7_3 0 0.02p
Raf8_7_4 naf8_7_3 naf8_7_4 169000.0
Caf8_7_4 naf8_7_4 0 0.02p
Raf8_7_5 naf8_7_4 a 169000.0
Raf8_8_0 af8in naf8_8_0 169000.0
Caf8_8_0 naf8_8_0 0 0.02p
Raf8_8_1 naf8_8_0 naf8_8_1 169000.0
Caf8_8_1 naf8_8_1 0 0.02p
Raf8_8_2 naf8_8_1 naf8_8_2 169000.0
Caf8_8_2 naf8_8_2 0 0.02p
Raf8_8_3 naf8_8_2 naf8_8_3 169000.0
Caf8_8_3 naf8_8_3 0 0.02p
Raf8_8_4 naf8_8_3 naf8_8_4 169000.0
Caf8_8_4 naf8_8_4 0 0.02p
Raf8_8_5 naf8_8_4 a 169000.0
Raf8_9_0 af8in naf8_9_0 169000.0
Caf8_9_0 naf8_9_0 0 0.02p
Raf8_9_1 naf8_9_0 naf8_9_1 169000.0
Caf8_9_1 naf8_9_1 0 0.02p
Raf8_9_2 naf8_9_1 naf8_9_2 169000.0
Caf8_9_2 naf8_9_2 0 0.02p
Raf8_9_3 naf8_9_2 naf8_9_3 169000.0
Caf8_9_3 naf8_9_3 0 0.02p
Raf8_9_4 naf8_9_3 naf8_9_4 169000.0
Caf8_9_4 naf8_9_4 0 0.02p
Raf8_9_5 naf8_9_4 a 169000.0
Raf8_10_0 af8in naf8_10_0 169000.0
Caf8_10_0 naf8_10_0 0 0.02p
Raf8_10_1 naf8_10_0 naf8_10_1 169000.0
Caf8_10_1 naf8_10_1 0 0.02p
Raf8_10_2 naf8_10_1 naf8_10_2 169000.0
Caf8_10_2 naf8_10_2 0 0.02p
Raf8_10_3 naf8_10_2 naf8_10_3 169000.0
Caf8_10_3 naf8_10_3 0 0.02p
Raf8_10_4 naf8_10_3 naf8_10_4 169000.0
Caf8_10_4 naf8_10_4 0 0.02p
Raf8_10_5 naf8_10_4 a 169000.0
Raf8_11_0 af8in naf8_11_0 169000.0
Caf8_11_0 naf8_11_0 0 0.02p
Raf8_11_1 naf8_11_0 naf8_11_1 169000.0
Caf8_11_1 naf8_11_1 0 0.02p
Raf8_11_2 naf8_11_1 naf8_11_2 169000.0
Caf8_11_2 naf8_11_2 0 0.02p
Raf8_11_3 naf8_11_2 naf8_11_3 169000.0
Caf8_11_3 naf8_11_3 0 0.02p
Raf8_11_4 naf8_11_3 naf8_11_4 169000.0
Caf8_11_4 naf8_11_4 0 0.02p
Raf8_11_5 naf8_11_4 a 169000.0
Raterm_0_0 0 naterm_0_0 169000.0
Caterm_0_0 naterm_0_0 0 0.02p
Raterm_0_1 naterm_0_0 naterm_0_1 169000.0
Caterm_0_1 naterm_0_1 0 0.02p
Raterm_0_2 naterm_0_1 naterm_0_2 169000.0
Caterm_0_2 naterm_0_2 0 0.02p
Raterm_0_3 naterm_0_2 naterm_0_3 169000.0
Caterm_0_3 naterm_0_3 0 0.02p
Raterm_0_4 naterm_0_3 naterm_0_4 169000.0
Caterm_0_4 naterm_0_4 0 0.02p
Raterm_0_5 naterm_0_4 naterm_0_5 169000.0
Caterm_0_5 naterm_0_5 0 0.02p
Raterm_0_6 naterm_0_5 naterm_0_6 169000.0
Caterm_0_6 naterm_0_6 0 0.02p
Raterm_0_7 naterm_0_6 naterm_0_7 169000.0
Caterm_0_7 naterm_0_7 0 0.02p
Raterm_0_8 naterm_0_7 naterm_0_8 169000.0
Caterm_0_8 naterm_0_8 0 0.02p
Raterm_0_9 naterm_0_8 naterm_0_9 169000.0
Caterm_0_9 naterm_0_9 0 0.02p
Raterm_0_10 naterm_0_9 naterm_0_10 169000.0
Caterm_0_10 naterm_0_10 0 0.02p
Raterm_0_11 naterm_0_10 naterm_0_11 169000.0
Caterm_0_11 naterm_0_11 0 0.02p
Raterm_0_12 naterm_0_11 naterm_0_12 169000.0
Caterm_0_12 naterm_0_12 0 0.02p
Raterm_0_13 naterm_0_12 naterm_0_13 169000.0
Caterm_0_13 naterm_0_13 0 0.02p
Raterm_0_14 naterm_0_13 naterm_0_14 169000.0
Caterm_0_14 naterm_0_14 0 0.02p
Raterm_0_15 naterm_0_14 naterm_0_15 169000.0
Caterm_0_15 naterm_0_15 0 0.02p
Raterm_0_16 naterm_0_15 naterm_0_16 169000.0
Caterm_0_16 naterm_0_16 0 0.02p
Raterm_0_17 naterm_0_16 naterm_0_17 169000.0
Caterm_0_17 naterm_0_17 0 0.02p
Raterm_0_18 naterm_0_17 naterm_0_18 169000.0
Caterm_0_18 naterm_0_18 0 0.02p
Raterm_0_19 naterm_0_18 naterm_0_19 169000.0
Caterm_0_19 naterm_0_19 0 0.02p
Raterm_0_20 naterm_0_19 naterm_0_20 169000.0
Caterm_0_20 naterm_0_20 0 0.02p
Raterm_0_21 naterm_0_20 naterm_0_21 169000.0
Caterm_0_21 naterm_0_21 0 0.02p
Raterm_0_22 naterm_0_21 naterm_0_22 169000.0
Caterm_0_22 naterm_0_22 0 0.02p
Raterm_0_23 naterm_0_22 naterm_0_23 169000.0
Caterm_0_23 naterm_0_23 0 0.02p
Raterm_0_24 naterm_0_23 naterm_0_24 169000.0
Caterm_0_24 naterm_0_24 0 0.02p
Raterm_0_25 naterm_0_24 naterm_0_25 169000.0
Caterm_0_25 naterm_0_25 0 0.02p
Raterm_0_26 naterm_0_25 naterm_0_26 169000.0
Caterm_0_26 naterm_0_26 0 0.02p
Raterm_0_27 naterm_0_26 naterm_0_27 169000.0
Caterm_0_27 naterm_0_27 0 0.02p
Raterm_0_28 naterm_0_27 naterm_0_28 169000.0
Caterm_0_28 naterm_0_28 0 0.02p
Raterm_0_29 naterm_0_28 naterm_0_29 169000.0
Caterm_0_29 naterm_0_29 0 0.02p
Raterm_0_30 naterm_0_29 naterm_0_30 169000.0
Caterm_0_30 naterm_0_30 0 0.02p
Raterm_0_31 naterm_0_30 naterm_0_31 169000.0
Caterm_0_31 naterm_0_31 0 0.02p
Raterm_0_32 naterm_0_31 naterm_0_32 169000.0
Caterm_0_32 naterm_0_32 0 0.02p
Raterm_0_33 naterm_0_32 naterm_0_33 169000.0
Caterm_0_33 naterm_0_33 0 0.02p
Raterm_0_34 naterm_0_33 naterm_0_34 169000.0
Caterm_0_34 naterm_0_34 0 0.02p
Raterm_0_35 naterm_0_34 naterm_0_35 169000.0
Caterm_0_35 naterm_0_35 0 0.02p
Raterm_0_36 naterm_0_35 naterm_0_36 169000.0
Caterm_0_36 naterm_0_36 0 0.02p
Raterm_0_37 naterm_0_36 naterm_0_37 169000.0
Caterm_0_37 naterm_0_37 0 0.02p
Raterm_0_38 naterm_0_37 naterm_0_38 169000.0
Caterm_0_38 naterm_0_38 0 0.02p
Raterm_0_39 naterm_0_38 naterm_0_39 169000.0
Caterm_0_39 naterm_0_39 0 0.02p
Raterm_0_40 naterm_0_39 naterm_0_40 169000.0
Caterm_0_40 naterm_0_40 0 0.02p
Raterm_0_41 naterm_0_40 naterm_0_41 169000.0
Caterm_0_41 naterm_0_41 0 0.02p
Raterm_0_42 naterm_0_41 naterm_0_42 169000.0
Caterm_0_42 naterm_0_42 0 0.02p
Raterm_0_43 naterm_0_42 naterm_0_43 169000.0
Caterm_0_43 naterm_0_43 0 0.02p
Raterm_0_44 naterm_0_43 naterm_0_44 169000.0
Caterm_0_44 naterm_0_44 0 0.02p
Raterm_0_45 naterm_0_44 naterm_0_45 169000.0
Caterm_0_45 naterm_0_45 0 0.02p
Raterm_0_46 naterm_0_45 naterm_0_46 169000.0
Caterm_0_46 naterm_0_46 0 0.02p
Raterm_0_47 naterm_0_46 naterm_0_47 169000.0
Caterm_0_47 naterm_0_47 0 0.02p
Raterm_0_48 naterm_0_47 naterm_0_48 169000.0
Caterm_0_48 naterm_0_48 0 0.02p
Raterm_0_49 naterm_0_48 naterm_0_49 169000.0
Caterm_0_49 naterm_0_49 0 0.02p
Raterm_0_50 naterm_0_49 naterm_0_50 169000.0
Caterm_0_50 naterm_0_50 0 0.02p
Raterm_0_51 naterm_0_50 naterm_0_51 169000.0
Caterm_0_51 naterm_0_51 0 0.02p
Raterm_0_52 naterm_0_51 naterm_0_52 169000.0
Caterm_0_52 naterm_0_52 0 0.02p
Raterm_0_53 naterm_0_52 naterm_0_53 169000.0
Caterm_0_53 naterm_0_53 0 0.02p
Raterm_0_54 naterm_0_53 naterm_0_54 169000.0
Caterm_0_54 naterm_0_54 0 0.02p
Raterm_0_55 naterm_0_54 naterm_0_55 169000.0
Caterm_0_55 naterm_0_55 0 0.02p
Raterm_0_56 naterm_0_55 naterm_0_56 169000.0
Caterm_0_56 naterm_0_56 0 0.02p
Raterm_0_57 naterm_0_56 naterm_0_57 169000.0
Caterm_0_57 naterm_0_57 0 0.02p
Raterm_0_58 naterm_0_57 naterm_0_58 169000.0
Caterm_0_58 naterm_0_58 0 0.02p
Raterm_0_59 naterm_0_58 naterm_0_59 169000.0
Caterm_0_59 naterm_0_59 0 0.02p
Raterm_0_60 naterm_0_59 naterm_0_60 169000.0
Caterm_0_60 naterm_0_60 0 0.02p
Raterm_0_61 naterm_0_60 naterm_0_61 169000.0
Caterm_0_61 naterm_0_61 0 0.02p
Raterm_0_62 naterm_0_61 naterm_0_62 169000.0
Caterm_0_62 naterm_0_62 0 0.02p
Raterm_0_63 naterm_0_62 naterm_0_63 169000.0
Caterm_0_63 naterm_0_63 0 0.02p
Raterm_0_64 naterm_0_63 naterm_0_64 169000.0
Caterm_0_64 naterm_0_64 0 0.02p
Raterm_0_65 naterm_0_64 naterm_0_65 169000.0
Caterm_0_65 naterm_0_65 0 0.02p
Raterm_0_66 naterm_0_65 naterm_0_66 169000.0
Caterm_0_66 naterm_0_66 0 0.02p
Raterm_0_67 naterm_0_66 naterm_0_67 169000.0
Caterm_0_67 naterm_0_67 0 0.02p
Raterm_0_68 naterm_0_67 naterm_0_68 169000.0
Caterm_0_68 naterm_0_68 0 0.02p
Raterm_0_69 naterm_0_68 naterm_0_69 169000.0
Caterm_0_69 naterm_0_69 0 0.02p
Raterm_0_70 naterm_0_69 naterm_0_70 169000.0
Caterm_0_70 naterm_0_70 0 0.02p
Raterm_0_71 naterm_0_70 naterm_0_71 169000.0
Caterm_0_71 naterm_0_71 0 0.02p
Raterm_0_72 naterm_0_71 naterm_0_72 169000.0
Caterm_0_72 naterm_0_72 0 0.02p
Raterm_0_73 naterm_0_72 naterm_0_73 169000.0
Caterm_0_73 naterm_0_73 0 0.02p
Raterm_0_74 naterm_0_73 naterm_0_74 169000.0
Caterm_0_74 naterm_0_74 0 0.02p
Raterm_0_75 naterm_0_74 naterm_0_75 169000.0
Caterm_0_75 naterm_0_75 0 0.02p
Raterm_0_76 naterm_0_75 naterm_0_76 169000.0
Caterm_0_76 naterm_0_76 0 0.02p
Raterm_0_77 naterm_0_76 naterm_0_77 169000.0
Caterm_0_77 naterm_0_77 0 0.02p
Raterm_0_78 naterm_0_77 naterm_0_78 169000.0
Caterm_0_78 naterm_0_78 0 0.02p
Raterm_0_79 naterm_0_78 naterm_0_79 169000.0
Caterm_0_79 naterm_0_79 0 0.02p
Raterm_0_80 naterm_0_79 naterm_0_80 169000.0
Caterm_0_80 naterm_0_80 0 0.02p
Raterm_0_81 naterm_0_80 naterm_0_81 169000.0
Caterm_0_81 naterm_0_81 0 0.02p
Raterm_0_82 naterm_0_81 naterm_0_82 169000.0
Caterm_0_82 naterm_0_82 0 0.02p
Raterm_0_83 naterm_0_82 naterm_0_83 169000.0
Caterm_0_83 naterm_0_83 0 0.02p
Raterm_0_84 naterm_0_83 naterm_0_84 169000.0
Caterm_0_84 naterm_0_84 0 0.02p
Raterm_0_85 naterm_0_84 naterm_0_85 169000.0
Caterm_0_85 naterm_0_85 0 0.02p
Raterm_0_86 naterm_0_85 naterm_0_86 169000.0
Caterm_0_86 naterm_0_86 0 0.02p
Raterm_0_87 naterm_0_86 naterm_0_87 169000.0
Caterm_0_87 naterm_0_87 0 0.02p
Raterm_0_88 naterm_0_87 naterm_0_88 169000.0
Caterm_0_88 naterm_0_88 0 0.02p
Raterm_0_89 naterm_0_88 naterm_0_89 169000.0
Caterm_0_89 naterm_0_89 0 0.02p
Raterm_0_90 naterm_0_89 naterm_0_90 169000.0
Caterm_0_90 naterm_0_90 0 0.02p
Raterm_0_91 naterm_0_90 naterm_0_91 169000.0
Caterm_0_91 naterm_0_91 0 0.02p
Raterm_0_92 naterm_0_91 naterm_0_92 169000.0
Caterm_0_92 naterm_0_92 0 0.02p
Raterm_0_93 naterm_0_92 naterm_0_93 169000.0
Caterm_0_93 naterm_0_93 0 0.02p
Raterm_0_94 naterm_0_93 naterm_0_94 169000.0
Caterm_0_94 naterm_0_94 0 0.02p
Raterm_0_95 naterm_0_94 naterm_0_95 169000.0
Caterm_0_95 naterm_0_95 0 0.02p
Raterm_0_96 naterm_0_95 naterm_0_96 169000.0
Caterm_0_96 naterm_0_96 0 0.02p
Raterm_0_97 naterm_0_96 naterm_0_97 169000.0
Caterm_0_97 naterm_0_97 0 0.02p
Raterm_0_98 naterm_0_97 naterm_0_98 169000.0
Caterm_0_98 naterm_0_98 0 0.02p
Raterm_0_99 naterm_0_98 naterm_0_99 169000.0
Caterm_0_99 naterm_0_99 0 0.02p
Raterm_0_100 naterm_0_99 naterm_0_100 169000.0
Caterm_0_100 naterm_0_100 0 0.02p
Raterm_0_101 naterm_0_100 naterm_0_101 169000.0
Caterm_0_101 naterm_0_101 0 0.02p
Raterm_0_102 naterm_0_101 naterm_0_102 169000.0
Caterm_0_102 naterm_0_102 0 0.02p
Raterm_0_103 naterm_0_102 naterm_0_103 169000.0
Caterm_0_103 naterm_0_103 0 0.02p
Raterm_0_104 naterm_0_103 naterm_0_104 169000.0
Caterm_0_104 naterm_0_104 0 0.02p
Raterm_0_105 naterm_0_104 naterm_0_105 169000.0
Caterm_0_105 naterm_0_105 0 0.02p
Raterm_0_106 naterm_0_105 naterm_0_106 169000.0
Caterm_0_106 naterm_0_106 0 0.02p
Raterm_0_107 naterm_0_106 naterm_0_107 169000.0
Caterm_0_107 naterm_0_107 0 0.02p
Raterm_0_108 naterm_0_107 naterm_0_108 169000.0
Caterm_0_108 naterm_0_108 0 0.02p
Raterm_0_109 naterm_0_108 naterm_0_109 169000.0
Caterm_0_109 naterm_0_109 0 0.02p
Raterm_0_110 naterm_0_109 naterm_0_110 169000.0
Caterm_0_110 naterm_0_110 0 0.02p
Raterm_0_111 naterm_0_110 naterm_0_111 169000.0
Caterm_0_111 naterm_0_111 0 0.02p
Raterm_0_112 naterm_0_111 naterm_0_112 169000.0
Caterm_0_112 naterm_0_112 0 0.02p
Raterm_0_113 naterm_0_112 naterm_0_113 169000.0
Caterm_0_113 naterm_0_113 0 0.02p
Raterm_0_114 naterm_0_113 naterm_0_114 169000.0
Caterm_0_114 naterm_0_114 0 0.02p
Raterm_0_115 naterm_0_114 naterm_0_115 169000.0
Caterm_0_115 naterm_0_115 0 0.02p
Raterm_0_116 naterm_0_115 naterm_0_116 169000.0
Caterm_0_116 naterm_0_116 0 0.02p
Raterm_0_117 naterm_0_116 naterm_0_117 169000.0
Caterm_0_117 naterm_0_117 0 0.02p
Raterm_0_118 naterm_0_117 naterm_0_118 169000.0
Caterm_0_118 naterm_0_118 0 0.02p
Raterm_0_119 naterm_0_118 naterm_0_119 169000.0
Caterm_0_119 naterm_0_119 0 0.02p
Raterm_0_120 naterm_0_119 naterm_0_120 169000.0
Caterm_0_120 naterm_0_120 0 0.02p
Raterm_0_121 naterm_0_120 naterm_0_121 169000.0
Caterm_0_121 naterm_0_121 0 0.02p
Raterm_0_122 naterm_0_121 naterm_0_122 169000.0
Caterm_0_122 naterm_0_122 0 0.02p
Raterm_0_123 naterm_0_122 naterm_0_123 169000.0
Caterm_0_123 naterm_0_123 0 0.02p
Raterm_0_124 naterm_0_123 naterm_0_124 169000.0
Caterm_0_124 naterm_0_124 0 0.02p
Raterm_0_125 naterm_0_124 naterm_0_125 169000.0
Caterm_0_125 naterm_0_125 0 0.02p
Raterm_0_126 naterm_0_125 naterm_0_126 169000.0
Caterm_0_126 naterm_0_126 0 0.02p
Raterm_0_127 naterm_0_126 a 169000.0
Vbc0 bc0in 0 DC 0 AC -0.5
Rbc0_0_0 bc0in nbc0_0_0 169000.0
Cbc0_0_0 nbc0_0_0 0 0.02p
Rbc0_0_1 nbc0_0_0 nbc0_0_1 169000.0
Cbc0_0_1 nbc0_0_1 0 0.02p
Rbc0_0_2 nbc0_0_1 nbc0_0_2 169000.0
Cbc0_0_2 nbc0_0_2 0 0.02p
Rbc0_0_3 nbc0_0_2 nbc0_0_3 169000.0
Cbc0_0_3 nbc0_0_3 0 0.02p
Rbc0_0_4 nbc0_0_3 nbc0_0_4 169000.0
Cbc0_0_4 nbc0_0_4 0 0.02p
Rbc0_0_5 nbc0_0_4 b 169000.0
Rbc0_1_0 bc0in nbc0_1_0 169000.0
Cbc0_1_0 nbc0_1_0 0 0.02p
Rbc0_1_1 nbc0_1_0 nbc0_1_1 169000.0
Cbc0_1_1 nbc0_1_1 0 0.02p
Rbc0_1_2 nbc0_1_1 nbc0_1_2 169000.0
Cbc0_1_2 nbc0_1_2 0 0.02p
Rbc0_1_3 nbc0_1_2 nbc0_1_3 169000.0
Cbc0_1_3 nbc0_1_3 0 0.02p
Rbc0_1_4 nbc0_1_3 nbc0_1_4 169000.0
Cbc0_1_4 nbc0_1_4 0 0.02p
Rbc0_1_5 nbc0_1_4 b 169000.0
Rbc0_2_0 bc0in nbc0_2_0 169000.0
Cbc0_2_0 nbc0_2_0 0 0.02p
Rbc0_2_1 nbc0_2_0 nbc0_2_1 169000.0
Cbc0_2_1 nbc0_2_1 0 0.02p
Rbc0_2_2 nbc0_2_1 nbc0_2_2 169000.0
Cbc0_2_2 nbc0_2_2 0 0.02p
Rbc0_2_3 nbc0_2_2 nbc0_2_3 169000.0
Cbc0_2_3 nbc0_2_3 0 0.02p
Rbc0_2_4 nbc0_2_3 nbc0_2_4 169000.0
Cbc0_2_4 nbc0_2_4 0 0.02p
Rbc0_2_5 nbc0_2_4 b 169000.0
Rbc0_3_0 bc0in nbc0_3_0 169000.0
Cbc0_3_0 nbc0_3_0 0 0.02p
Rbc0_3_1 nbc0_3_0 nbc0_3_1 169000.0
Cbc0_3_1 nbc0_3_1 0 0.02p
Rbc0_3_2 nbc0_3_1 nbc0_3_2 169000.0
Cbc0_3_2 nbc0_3_2 0 0.02p
Rbc0_3_3 nbc0_3_2 nbc0_3_3 169000.0
Cbc0_3_3 nbc0_3_3 0 0.02p
Rbc0_3_4 nbc0_3_3 nbc0_3_4 169000.0
Cbc0_3_4 nbc0_3_4 0 0.02p
Rbc0_3_5 nbc0_3_4 b 169000.0
Rbc0_4_0 bc0in nbc0_4_0 169000.0
Cbc0_4_0 nbc0_4_0 0 0.02p
Rbc0_4_1 nbc0_4_0 nbc0_4_1 169000.0
Cbc0_4_1 nbc0_4_1 0 0.02p
Rbc0_4_2 nbc0_4_1 nbc0_4_2 169000.0
Cbc0_4_2 nbc0_4_2 0 0.02p
Rbc0_4_3 nbc0_4_2 nbc0_4_3 169000.0
Cbc0_4_3 nbc0_4_3 0 0.02p
Rbc0_4_4 nbc0_4_3 nbc0_4_4 169000.0
Cbc0_4_4 nbc0_4_4 0 0.02p
Rbc0_4_5 nbc0_4_4 b 169000.0
Rbc0_5_0 bc0in nbc0_5_0 169000.0
Cbc0_5_0 nbc0_5_0 0 0.02p
Rbc0_5_1 nbc0_5_0 nbc0_5_1 169000.0
Cbc0_5_1 nbc0_5_1 0 0.02p
Rbc0_5_2 nbc0_5_1 nbc0_5_2 169000.0
Cbc0_5_2 nbc0_5_2 0 0.02p
Rbc0_5_3 nbc0_5_2 nbc0_5_3 169000.0
Cbc0_5_3 nbc0_5_3 0 0.02p
Rbc0_5_4 nbc0_5_3 nbc0_5_4 169000.0
Cbc0_5_4 nbc0_5_4 0 0.02p
Rbc0_5_5 nbc0_5_4 b 169000.0
Rbc0_6_0 bc0in nbc0_6_0 169000.0
Cbc0_6_0 nbc0_6_0 0 0.02p
Rbc0_6_1 nbc0_6_0 nbc0_6_1 169000.0
Cbc0_6_1 nbc0_6_1 0 0.02p
Rbc0_6_2 nbc0_6_1 nbc0_6_2 169000.0
Cbc0_6_2 nbc0_6_2 0 0.02p
Rbc0_6_3 nbc0_6_2 nbc0_6_3 169000.0
Cbc0_6_3 nbc0_6_3 0 0.02p
Rbc0_6_4 nbc0_6_3 nbc0_6_4 169000.0
Cbc0_6_4 nbc0_6_4 0 0.02p
Rbc0_6_5 nbc0_6_4 b 169000.0
Rbc0_7_0 bc0in nbc0_7_0 169000.0
Cbc0_7_0 nbc0_7_0 0 0.02p
Rbc0_7_1 nbc0_7_0 nbc0_7_1 169000.0
Cbc0_7_1 nbc0_7_1 0 0.02p
Rbc0_7_2 nbc0_7_1 nbc0_7_2 169000.0
Cbc0_7_2 nbc0_7_2 0 0.02p
Rbc0_7_3 nbc0_7_2 nbc0_7_3 169000.0
Cbc0_7_3 nbc0_7_3 0 0.02p
Rbc0_7_4 nbc0_7_3 nbc0_7_4 169000.0
Cbc0_7_4 nbc0_7_4 0 0.02p
Rbc0_7_5 nbc0_7_4 b 169000.0
Rbc0_8_0 bc0in nbc0_8_0 169000.0
Cbc0_8_0 nbc0_8_0 0 0.02p
Rbc0_8_1 nbc0_8_0 nbc0_8_1 169000.0
Cbc0_8_1 nbc0_8_1 0 0.02p
Rbc0_8_2 nbc0_8_1 nbc0_8_2 169000.0
Cbc0_8_2 nbc0_8_2 0 0.02p
Rbc0_8_3 nbc0_8_2 nbc0_8_3 169000.0
Cbc0_8_3 nbc0_8_3 0 0.02p
Rbc0_8_4 nbc0_8_3 nbc0_8_4 169000.0
Cbc0_8_4 nbc0_8_4 0 0.02p
Rbc0_8_5 nbc0_8_4 b 169000.0
Rbc0_9_0 bc0in nbc0_9_0 169000.0
Cbc0_9_0 nbc0_9_0 0 0.02p
Rbc0_9_1 nbc0_9_0 nbc0_9_1 169000.0
Cbc0_9_1 nbc0_9_1 0 0.02p
Rbc0_9_2 nbc0_9_1 nbc0_9_2 169000.0
Cbc0_9_2 nbc0_9_2 0 0.02p
Rbc0_9_3 nbc0_9_2 nbc0_9_3 169000.0
Cbc0_9_3 nbc0_9_3 0 0.02p
Rbc0_9_4 nbc0_9_3 nbc0_9_4 169000.0
Cbc0_9_4 nbc0_9_4 0 0.02p
Rbc0_9_5 nbc0_9_4 b 169000.0
Rbc0_10_0 bc0in nbc0_10_0 169000.0
Cbc0_10_0 nbc0_10_0 0 0.02p
Rbc0_10_1 nbc0_10_0 nbc0_10_1 169000.0
Cbc0_10_1 nbc0_10_1 0 0.02p
Rbc0_10_2 nbc0_10_1 nbc0_10_2 169000.0
Cbc0_10_2 nbc0_10_2 0 0.02p
Rbc0_10_3 nbc0_10_2 nbc0_10_3 169000.0
Cbc0_10_3 nbc0_10_3 0 0.02p
Rbc0_10_4 nbc0_10_3 nbc0_10_4 169000.0
Cbc0_10_4 nbc0_10_4 0 0.02p
Rbc0_10_5 nbc0_10_4 b 169000.0
Rbc0_11_0 bc0in nbc0_11_0 169000.0
Cbc0_11_0 nbc0_11_0 0 0.02p
Rbc0_11_1 nbc0_11_0 nbc0_11_1 169000.0
Cbc0_11_1 nbc0_11_1 0 0.02p
Rbc0_11_2 nbc0_11_1 nbc0_11_2 169000.0
Cbc0_11_2 nbc0_11_2 0 0.02p
Rbc0_11_3 nbc0_11_2 nbc0_11_3 169000.0
Cbc0_11_3 nbc0_11_3 0 0.02p
Rbc0_11_4 nbc0_11_3 nbc0_11_4 169000.0
Cbc0_11_4 nbc0_11_4 0 0.02p
Rbc0_11_5 nbc0_11_4 b 169000.0
Rbc0_12_0 bc0in nbc0_12_0 169000.0
Cbc0_12_0 nbc0_12_0 0 0.02p
Rbc0_12_1 nbc0_12_0 nbc0_12_1 169000.0
Cbc0_12_1 nbc0_12_1 0 0.02p
Rbc0_12_2 nbc0_12_1 nbc0_12_2 169000.0
Cbc0_12_2 nbc0_12_2 0 0.02p
Rbc0_12_3 nbc0_12_2 nbc0_12_3 169000.0
Cbc0_12_3 nbc0_12_3 0 0.02p
Rbc0_12_4 nbc0_12_3 nbc0_12_4 169000.0
Cbc0_12_4 nbc0_12_4 0 0.02p
Rbc0_12_5 nbc0_12_4 b 169000.0
Rbc0_13_0 bc0in nbc0_13_0 169000.0
Cbc0_13_0 nbc0_13_0 0 0.02p
Rbc0_13_1 nbc0_13_0 nbc0_13_1 169000.0
Cbc0_13_1 nbc0_13_1 0 0.02p
Rbc0_13_2 nbc0_13_1 nbc0_13_2 169000.0
Cbc0_13_2 nbc0_13_2 0 0.02p
Rbc0_13_3 nbc0_13_2 nbc0_13_3 169000.0
Cbc0_13_3 nbc0_13_3 0 0.02p
Rbc0_13_4 nbc0_13_3 nbc0_13_4 169000.0
Cbc0_13_4 nbc0_13_4 0 0.02p
Rbc0_13_5 nbc0_13_4 b 169000.0
Rbc0_14_0 bc0in nbc0_14_0 169000.0
Cbc0_14_0 nbc0_14_0 0 0.02p
Rbc0_14_1 nbc0_14_0 nbc0_14_1 169000.0
Cbc0_14_1 nbc0_14_1 0 0.02p
Rbc0_14_2 nbc0_14_1 nbc0_14_2 169000.0
Cbc0_14_2 nbc0_14_2 0 0.02p
Rbc0_14_3 nbc0_14_2 nbc0_14_3 169000.0
Cbc0_14_3 nbc0_14_3 0 0.02p
Rbc0_14_4 nbc0_14_3 nbc0_14_4 169000.0
Cbc0_14_4 nbc0_14_4 0 0.02p
Rbc0_14_5 nbc0_14_4 b 169000.0
Rbc0_15_0 bc0in nbc0_15_0 169000.0
Cbc0_15_0 nbc0_15_0 0 0.02p
Rbc0_15_1 nbc0_15_0 nbc0_15_1 169000.0
Cbc0_15_1 nbc0_15_1 0 0.02p
Rbc0_15_2 nbc0_15_1 nbc0_15_2 169000.0
Cbc0_15_2 nbc0_15_2 0 0.02p
Rbc0_15_3 nbc0_15_2 nbc0_15_3 169000.0
Cbc0_15_3 nbc0_15_3 0 0.02p
Rbc0_15_4 nbc0_15_3 nbc0_15_4 169000.0
Cbc0_15_4 nbc0_15_4 0 0.02p
Rbc0_15_5 nbc0_15_4 b 169000.0
Rbc0_16_0 bc0in nbc0_16_0 169000.0
Cbc0_16_0 nbc0_16_0 0 0.02p
Rbc0_16_1 nbc0_16_0 nbc0_16_1 169000.0
Cbc0_16_1 nbc0_16_1 0 0.02p
Rbc0_16_2 nbc0_16_1 nbc0_16_2 169000.0
Cbc0_16_2 nbc0_16_2 0 0.02p
Rbc0_16_3 nbc0_16_2 nbc0_16_3 169000.0
Cbc0_16_3 nbc0_16_3 0 0.02p
Rbc0_16_4 nbc0_16_3 nbc0_16_4 169000.0
Cbc0_16_4 nbc0_16_4 0 0.02p
Rbc0_16_5 nbc0_16_4 b 169000.0
Rbc0_17_0 bc0in nbc0_17_0 169000.0
Cbc0_17_0 nbc0_17_0 0 0.02p
Rbc0_17_1 nbc0_17_0 nbc0_17_1 169000.0
Cbc0_17_1 nbc0_17_1 0 0.02p
Rbc0_17_2 nbc0_17_1 nbc0_17_2 169000.0
Cbc0_17_2 nbc0_17_2 0 0.02p
Rbc0_17_3 nbc0_17_2 nbc0_17_3 169000.0
Cbc0_17_3 nbc0_17_3 0 0.02p
Rbc0_17_4 nbc0_17_3 nbc0_17_4 169000.0
Cbc0_17_4 nbc0_17_4 0 0.02p
Rbc0_17_5 nbc0_17_4 b 169000.0
Rbc0_18_0 bc0in nbc0_18_0 169000.0
Cbc0_18_0 nbc0_18_0 0 0.02p
Rbc0_18_1 nbc0_18_0 nbc0_18_1 169000.0
Cbc0_18_1 nbc0_18_1 0 0.02p
Rbc0_18_2 nbc0_18_1 nbc0_18_2 169000.0
Cbc0_18_2 nbc0_18_2 0 0.02p
Rbc0_18_3 nbc0_18_2 nbc0_18_3 169000.0
Cbc0_18_3 nbc0_18_3 0 0.02p
Rbc0_18_4 nbc0_18_3 nbc0_18_4 169000.0
Cbc0_18_4 nbc0_18_4 0 0.02p
Rbc0_18_5 nbc0_18_4 b 169000.0
Rbc0_19_0 bc0in nbc0_19_0 169000.0
Cbc0_19_0 nbc0_19_0 0 0.02p
Rbc0_19_1 nbc0_19_0 nbc0_19_1 169000.0
Cbc0_19_1 nbc0_19_1 0 0.02p
Rbc0_19_2 nbc0_19_1 nbc0_19_2 169000.0
Cbc0_19_2 nbc0_19_2 0 0.02p
Rbc0_19_3 nbc0_19_2 nbc0_19_3 169000.0
Cbc0_19_3 nbc0_19_3 0 0.02p
Rbc0_19_4 nbc0_19_3 nbc0_19_4 169000.0
Cbc0_19_4 nbc0_19_4 0 0.02p
Rbc0_19_5 nbc0_19_4 b 169000.0
Rbc0_20_0 bc0in nbc0_20_0 169000.0
Cbc0_20_0 nbc0_20_0 0 0.02p
Rbc0_20_1 nbc0_20_0 nbc0_20_1 169000.0
Cbc0_20_1 nbc0_20_1 0 0.02p
Rbc0_20_2 nbc0_20_1 nbc0_20_2 169000.0
Cbc0_20_2 nbc0_20_2 0 0.02p
Rbc0_20_3 nbc0_20_2 nbc0_20_3 169000.0
Cbc0_20_3 nbc0_20_3 0 0.02p
Rbc0_20_4 nbc0_20_3 nbc0_20_4 169000.0
Cbc0_20_4 nbc0_20_4 0 0.02p
Rbc0_20_5 nbc0_20_4 b 169000.0
Rbc0_21_0 bc0in nbc0_21_0 169000.0
Cbc0_21_0 nbc0_21_0 0 0.02p
Rbc0_21_1 nbc0_21_0 nbc0_21_1 169000.0
Cbc0_21_1 nbc0_21_1 0 0.02p
Rbc0_21_2 nbc0_21_1 nbc0_21_2 169000.0
Cbc0_21_2 nbc0_21_2 0 0.02p
Rbc0_21_3 nbc0_21_2 nbc0_21_3 169000.0
Cbc0_21_3 nbc0_21_3 0 0.02p
Rbc0_21_4 nbc0_21_3 nbc0_21_4 169000.0
Cbc0_21_4 nbc0_21_4 0 0.02p
Rbc0_21_5 nbc0_21_4 b 169000.0
Rbc0_22_0 bc0in nbc0_22_0 169000.0
Cbc0_22_0 nbc0_22_0 0 0.02p
Rbc0_22_1 nbc0_22_0 nbc0_22_1 169000.0
Cbc0_22_1 nbc0_22_1 0 0.02p
Rbc0_22_2 nbc0_22_1 nbc0_22_2 169000.0
Cbc0_22_2 nbc0_22_2 0 0.02p
Rbc0_22_3 nbc0_22_2 nbc0_22_3 169000.0
Cbc0_22_3 nbc0_22_3 0 0.02p
Rbc0_22_4 nbc0_22_3 nbc0_22_4 169000.0
Cbc0_22_4 nbc0_22_4 0 0.02p
Rbc0_22_5 nbc0_22_4 b 169000.0
Rbc0_23_0 bc0in nbc0_23_0 169000.0
Cbc0_23_0 nbc0_23_0 0 0.02p
Rbc0_23_1 nbc0_23_0 nbc0_23_1 169000.0
Cbc0_23_1 nbc0_23_1 0 0.02p
Rbc0_23_2 nbc0_23_1 nbc0_23_2 169000.0
Cbc0_23_2 nbc0_23_2 0 0.02p
Rbc0_23_3 nbc0_23_2 nbc0_23_3 169000.0
Cbc0_23_3 nbc0_23_3 0 0.02p
Rbc0_23_4 nbc0_23_3 nbc0_23_4 169000.0
Cbc0_23_4 nbc0_23_4 0 0.02p
Rbc0_23_5 nbc0_23_4 b 169000.0
Vbc1 bc1in 0 DC 0 AC -0.5
Rbc1_0_0 bc1in nbc1_0_0 169000.0
Cbc1_0_0 nbc1_0_0 0 0.02p
Rbc1_0_1 nbc1_0_0 nbc1_0_1 169000.0
Cbc1_0_1 nbc1_0_1 0 0.02p
Rbc1_0_2 nbc1_0_1 nbc1_0_2 169000.0
Cbc1_0_2 nbc1_0_2 0 0.02p
Rbc1_0_3 nbc1_0_2 nbc1_0_3 169000.0
Cbc1_0_3 nbc1_0_3 0 0.02p
Rbc1_0_4 nbc1_0_3 nbc1_0_4 169000.0
Cbc1_0_4 nbc1_0_4 0 0.02p
Rbc1_0_5 nbc1_0_4 b 169000.0
Rbc1_1_0 bc1in nbc1_1_0 169000.0
Cbc1_1_0 nbc1_1_0 0 0.02p
Rbc1_1_1 nbc1_1_0 nbc1_1_1 169000.0
Cbc1_1_1 nbc1_1_1 0 0.02p
Rbc1_1_2 nbc1_1_1 nbc1_1_2 169000.0
Cbc1_1_2 nbc1_1_2 0 0.02p
Rbc1_1_3 nbc1_1_2 nbc1_1_3 169000.0
Cbc1_1_3 nbc1_1_3 0 0.02p
Rbc1_1_4 nbc1_1_3 nbc1_1_4 169000.0
Cbc1_1_4 nbc1_1_4 0 0.02p
Rbc1_1_5 nbc1_1_4 b 169000.0
Rbc1_2_0 bc1in nbc1_2_0 169000.0
Cbc1_2_0 nbc1_2_0 0 0.02p
Rbc1_2_1 nbc1_2_0 nbc1_2_1 169000.0
Cbc1_2_1 nbc1_2_1 0 0.02p
Rbc1_2_2 nbc1_2_1 nbc1_2_2 169000.0
Cbc1_2_2 nbc1_2_2 0 0.02p
Rbc1_2_3 nbc1_2_2 nbc1_2_3 169000.0
Cbc1_2_3 nbc1_2_3 0 0.02p
Rbc1_2_4 nbc1_2_3 nbc1_2_4 169000.0
Cbc1_2_4 nbc1_2_4 0 0.02p
Rbc1_2_5 nbc1_2_4 b 169000.0
Rbc1_3_0 bc1in nbc1_3_0 169000.0
Cbc1_3_0 nbc1_3_0 0 0.02p
Rbc1_3_1 nbc1_3_0 nbc1_3_1 169000.0
Cbc1_3_1 nbc1_3_1 0 0.02p
Rbc1_3_2 nbc1_3_1 nbc1_3_2 169000.0
Cbc1_3_2 nbc1_3_2 0 0.02p
Rbc1_3_3 nbc1_3_2 nbc1_3_3 169000.0
Cbc1_3_3 nbc1_3_3 0 0.02p
Rbc1_3_4 nbc1_3_3 nbc1_3_4 169000.0
Cbc1_3_4 nbc1_3_4 0 0.02p
Rbc1_3_5 nbc1_3_4 b 169000.0
Rbc1_4_0 bc1in nbc1_4_0 169000.0
Cbc1_4_0 nbc1_4_0 0 0.02p
Rbc1_4_1 nbc1_4_0 nbc1_4_1 169000.0
Cbc1_4_1 nbc1_4_1 0 0.02p
Rbc1_4_2 nbc1_4_1 nbc1_4_2 169000.0
Cbc1_4_2 nbc1_4_2 0 0.02p
Rbc1_4_3 nbc1_4_2 nbc1_4_3 169000.0
Cbc1_4_3 nbc1_4_3 0 0.02p
Rbc1_4_4 nbc1_4_3 nbc1_4_4 169000.0
Cbc1_4_4 nbc1_4_4 0 0.02p
Rbc1_4_5 nbc1_4_4 b 169000.0
Rbc1_5_0 bc1in nbc1_5_0 169000.0
Cbc1_5_0 nbc1_5_0 0 0.02p
Rbc1_5_1 nbc1_5_0 nbc1_5_1 169000.0
Cbc1_5_1 nbc1_5_1 0 0.02p
Rbc1_5_2 nbc1_5_1 nbc1_5_2 169000.0
Cbc1_5_2 nbc1_5_2 0 0.02p
Rbc1_5_3 nbc1_5_2 nbc1_5_3 169000.0
Cbc1_5_3 nbc1_5_3 0 0.02p
Rbc1_5_4 nbc1_5_3 nbc1_5_4 169000.0
Cbc1_5_4 nbc1_5_4 0 0.02p
Rbc1_5_5 nbc1_5_4 b 169000.0
Rbc1_6_0 bc1in nbc1_6_0 169000.0
Cbc1_6_0 nbc1_6_0 0 0.02p
Rbc1_6_1 nbc1_6_0 nbc1_6_1 169000.0
Cbc1_6_1 nbc1_6_1 0 0.02p
Rbc1_6_2 nbc1_6_1 nbc1_6_2 169000.0
Cbc1_6_2 nbc1_6_2 0 0.02p
Rbc1_6_3 nbc1_6_2 nbc1_6_3 169000.0
Cbc1_6_3 nbc1_6_3 0 0.02p
Rbc1_6_4 nbc1_6_3 nbc1_6_4 169000.0
Cbc1_6_4 nbc1_6_4 0 0.02p
Rbc1_6_5 nbc1_6_4 b 169000.0
Rbc1_7_0 bc1in nbc1_7_0 169000.0
Cbc1_7_0 nbc1_7_0 0 0.02p
Rbc1_7_1 nbc1_7_0 nbc1_7_1 169000.0
Cbc1_7_1 nbc1_7_1 0 0.02p
Rbc1_7_2 nbc1_7_1 nbc1_7_2 169000.0
Cbc1_7_2 nbc1_7_2 0 0.02p
Rbc1_7_3 nbc1_7_2 nbc1_7_3 169000.0
Cbc1_7_3 nbc1_7_3 0 0.02p
Rbc1_7_4 nbc1_7_3 nbc1_7_4 169000.0
Cbc1_7_4 nbc1_7_4 0 0.02p
Rbc1_7_5 nbc1_7_4 b 169000.0
Rbc1_8_0 bc1in nbc1_8_0 169000.0
Cbc1_8_0 nbc1_8_0 0 0.02p
Rbc1_8_1 nbc1_8_0 nbc1_8_1 169000.0
Cbc1_8_1 nbc1_8_1 0 0.02p
Rbc1_8_2 nbc1_8_1 nbc1_8_2 169000.0
Cbc1_8_2 nbc1_8_2 0 0.02p
Rbc1_8_3 nbc1_8_2 nbc1_8_3 169000.0
Cbc1_8_3 nbc1_8_3 0 0.02p
Rbc1_8_4 nbc1_8_3 nbc1_8_4 169000.0
Cbc1_8_4 nbc1_8_4 0 0.02p
Rbc1_8_5 nbc1_8_4 b 169000.0
Rbc1_9_0 bc1in nbc1_9_0 169000.0
Cbc1_9_0 nbc1_9_0 0 0.02p
Rbc1_9_1 nbc1_9_0 nbc1_9_1 169000.0
Cbc1_9_1 nbc1_9_1 0 0.02p
Rbc1_9_2 nbc1_9_1 nbc1_9_2 169000.0
Cbc1_9_2 nbc1_9_2 0 0.02p
Rbc1_9_3 nbc1_9_2 nbc1_9_3 169000.0
Cbc1_9_3 nbc1_9_3 0 0.02p
Rbc1_9_4 nbc1_9_3 nbc1_9_4 169000.0
Cbc1_9_4 nbc1_9_4 0 0.02p
Rbc1_9_5 nbc1_9_4 b 169000.0
Rbc1_10_0 bc1in nbc1_10_0 169000.0
Cbc1_10_0 nbc1_10_0 0 0.02p
Rbc1_10_1 nbc1_10_0 nbc1_10_1 169000.0
Cbc1_10_1 nbc1_10_1 0 0.02p
Rbc1_10_2 nbc1_10_1 nbc1_10_2 169000.0
Cbc1_10_2 nbc1_10_2 0 0.02p
Rbc1_10_3 nbc1_10_2 nbc1_10_3 169000.0
Cbc1_10_3 nbc1_10_3 0 0.02p
Rbc1_10_4 nbc1_10_3 nbc1_10_4 169000.0
Cbc1_10_4 nbc1_10_4 0 0.02p
Rbc1_10_5 nbc1_10_4 b 169000.0
Rbc1_11_0 bc1in nbc1_11_0 169000.0
Cbc1_11_0 nbc1_11_0 0 0.02p
Rbc1_11_1 nbc1_11_0 nbc1_11_1 169000.0
Cbc1_11_1 nbc1_11_1 0 0.02p
Rbc1_11_2 nbc1_11_1 nbc1_11_2 169000.0
Cbc1_11_2 nbc1_11_2 0 0.02p
Rbc1_11_3 nbc1_11_2 nbc1_11_3 169000.0
Cbc1_11_3 nbc1_11_3 0 0.02p
Rbc1_11_4 nbc1_11_3 nbc1_11_4 169000.0
Cbc1_11_4 nbc1_11_4 0 0.02p
Rbc1_11_5 nbc1_11_4 b 169000.0
Rbc1_12_0 bc1in nbc1_12_0 169000.0
Cbc1_12_0 nbc1_12_0 0 0.02p
Rbc1_12_1 nbc1_12_0 nbc1_12_1 169000.0
Cbc1_12_1 nbc1_12_1 0 0.02p
Rbc1_12_2 nbc1_12_1 nbc1_12_2 169000.0
Cbc1_12_2 nbc1_12_2 0 0.02p
Rbc1_12_3 nbc1_12_2 nbc1_12_3 169000.0
Cbc1_12_3 nbc1_12_3 0 0.02p
Rbc1_12_4 nbc1_12_3 nbc1_12_4 169000.0
Cbc1_12_4 nbc1_12_4 0 0.02p
Rbc1_12_5 nbc1_12_4 b 169000.0
Rbc1_13_0 bc1in nbc1_13_0 169000.0
Cbc1_13_0 nbc1_13_0 0 0.02p
Rbc1_13_1 nbc1_13_0 nbc1_13_1 169000.0
Cbc1_13_1 nbc1_13_1 0 0.02p
Rbc1_13_2 nbc1_13_1 nbc1_13_2 169000.0
Cbc1_13_2 nbc1_13_2 0 0.02p
Rbc1_13_3 nbc1_13_2 nbc1_13_3 169000.0
Cbc1_13_3 nbc1_13_3 0 0.02p
Rbc1_13_4 nbc1_13_3 nbc1_13_4 169000.0
Cbc1_13_4 nbc1_13_4 0 0.02p
Rbc1_13_5 nbc1_13_4 b 169000.0
Rbc1_14_0 bc1in nbc1_14_0 169000.0
Cbc1_14_0 nbc1_14_0 0 0.02p
Rbc1_14_1 nbc1_14_0 nbc1_14_1 169000.0
Cbc1_14_1 nbc1_14_1 0 0.02p
Rbc1_14_2 nbc1_14_1 nbc1_14_2 169000.0
Cbc1_14_2 nbc1_14_2 0 0.02p
Rbc1_14_3 nbc1_14_2 nbc1_14_3 169000.0
Cbc1_14_3 nbc1_14_3 0 0.02p
Rbc1_14_4 nbc1_14_3 nbc1_14_4 169000.0
Cbc1_14_4 nbc1_14_4 0 0.02p
Rbc1_14_5 nbc1_14_4 b 169000.0
Rbc1_15_0 bc1in nbc1_15_0 169000.0
Cbc1_15_0 nbc1_15_0 0 0.02p
Rbc1_15_1 nbc1_15_0 nbc1_15_1 169000.0
Cbc1_15_1 nbc1_15_1 0 0.02p
Rbc1_15_2 nbc1_15_1 nbc1_15_2 169000.0
Cbc1_15_2 nbc1_15_2 0 0.02p
Rbc1_15_3 nbc1_15_2 nbc1_15_3 169000.0
Cbc1_15_3 nbc1_15_3 0 0.02p
Rbc1_15_4 nbc1_15_3 nbc1_15_4 169000.0
Cbc1_15_4 nbc1_15_4 0 0.02p
Rbc1_15_5 nbc1_15_4 b 169000.0
Rbc1_16_0 bc1in nbc1_16_0 169000.0
Cbc1_16_0 nbc1_16_0 0 0.02p
Rbc1_16_1 nbc1_16_0 nbc1_16_1 169000.0
Cbc1_16_1 nbc1_16_1 0 0.02p
Rbc1_16_2 nbc1_16_1 nbc1_16_2 169000.0
Cbc1_16_2 nbc1_16_2 0 0.02p
Rbc1_16_3 nbc1_16_2 nbc1_16_3 169000.0
Cbc1_16_3 nbc1_16_3 0 0.02p
Rbc1_16_4 nbc1_16_3 nbc1_16_4 169000.0
Cbc1_16_4 nbc1_16_4 0 0.02p
Rbc1_16_5 nbc1_16_4 b 169000.0
Rbc1_17_0 bc1in nbc1_17_0 169000.0
Cbc1_17_0 nbc1_17_0 0 0.02p
Rbc1_17_1 nbc1_17_0 nbc1_17_1 169000.0
Cbc1_17_1 nbc1_17_1 0 0.02p
Rbc1_17_2 nbc1_17_1 nbc1_17_2 169000.0
Cbc1_17_2 nbc1_17_2 0 0.02p
Rbc1_17_3 nbc1_17_2 nbc1_17_3 169000.0
Cbc1_17_3 nbc1_17_3 0 0.02p
Rbc1_17_4 nbc1_17_3 nbc1_17_4 169000.0
Cbc1_17_4 nbc1_17_4 0 0.02p
Rbc1_17_5 nbc1_17_4 b 169000.0
Rbc1_18_0 bc1in nbc1_18_0 169000.0
Cbc1_18_0 nbc1_18_0 0 0.02p
Rbc1_18_1 nbc1_18_0 nbc1_18_1 169000.0
Cbc1_18_1 nbc1_18_1 0 0.02p
Rbc1_18_2 nbc1_18_1 nbc1_18_2 169000.0
Cbc1_18_2 nbc1_18_2 0 0.02p
Rbc1_18_3 nbc1_18_2 nbc1_18_3 169000.0
Cbc1_18_3 nbc1_18_3 0 0.02p
Rbc1_18_4 nbc1_18_3 nbc1_18_4 169000.0
Cbc1_18_4 nbc1_18_4 0 0.02p
Rbc1_18_5 nbc1_18_4 b 169000.0
Rbc1_19_0 bc1in nbc1_19_0 169000.0
Cbc1_19_0 nbc1_19_0 0 0.02p
Rbc1_19_1 nbc1_19_0 nbc1_19_1 169000.0
Cbc1_19_1 nbc1_19_1 0 0.02p
Rbc1_19_2 nbc1_19_1 nbc1_19_2 169000.0
Cbc1_19_2 nbc1_19_2 0 0.02p
Rbc1_19_3 nbc1_19_2 nbc1_19_3 169000.0
Cbc1_19_3 nbc1_19_3 0 0.02p
Rbc1_19_4 nbc1_19_3 nbc1_19_4 169000.0
Cbc1_19_4 nbc1_19_4 0 0.02p
Rbc1_19_5 nbc1_19_4 b 169000.0
Rbc1_20_0 bc1in nbc1_20_0 169000.0
Cbc1_20_0 nbc1_20_0 0 0.02p
Rbc1_20_1 nbc1_20_0 nbc1_20_1 169000.0
Cbc1_20_1 nbc1_20_1 0 0.02p
Rbc1_20_2 nbc1_20_1 nbc1_20_2 169000.0
Cbc1_20_2 nbc1_20_2 0 0.02p
Rbc1_20_3 nbc1_20_2 nbc1_20_3 169000.0
Cbc1_20_3 nbc1_20_3 0 0.02p
Rbc1_20_4 nbc1_20_3 nbc1_20_4 169000.0
Cbc1_20_4 nbc1_20_4 0 0.02p
Rbc1_20_5 nbc1_20_4 b 169000.0
Rbc1_21_0 bc1in nbc1_21_0 169000.0
Cbc1_21_0 nbc1_21_0 0 0.02p
Rbc1_21_1 nbc1_21_0 nbc1_21_1 169000.0
Cbc1_21_1 nbc1_21_1 0 0.02p
Rbc1_21_2 nbc1_21_1 nbc1_21_2 169000.0
Cbc1_21_2 nbc1_21_2 0 0.02p
Rbc1_21_3 nbc1_21_2 nbc1_21_3 169000.0
Cbc1_21_3 nbc1_21_3 0 0.02p
Rbc1_21_4 nbc1_21_3 nbc1_21_4 169000.0
Cbc1_21_4 nbc1_21_4 0 0.02p
Rbc1_21_5 nbc1_21_4 b 169000.0
Rbc1_22_0 bc1in nbc1_22_0 169000.0
Cbc1_22_0 nbc1_22_0 0 0.02p
Rbc1_22_1 nbc1_22_0 nbc1_22_1 169000.0
Cbc1_22_1 nbc1_22_1 0 0.02p
Rbc1_22_2 nbc1_22_1 nbc1_22_2 169000.0
Cbc1_22_2 nbc1_22_2 0 0.02p
Rbc1_22_3 nbc1_22_2 nbc1_22_3 169000.0
Cbc1_22_3 nbc1_22_3 0 0.02p
Rbc1_22_4 nbc1_22_3 nbc1_22_4 169000.0
Cbc1_22_4 nbc1_22_4 0 0.02p
Rbc1_22_5 nbc1_22_4 b 169000.0
Rbc1_23_0 bc1in nbc1_23_0 169000.0
Cbc1_23_0 nbc1_23_0 0 0.02p
Rbc1_23_1 nbc1_23_0 nbc1_23_1 169000.0
Cbc1_23_1 nbc1_23_1 0 0.02p
Rbc1_23_2 nbc1_23_1 nbc1_23_2 169000.0
Cbc1_23_2 nbc1_23_2 0 0.02p
Rbc1_23_3 nbc1_23_2 nbc1_23_3 169000.0
Cbc1_23_3 nbc1_23_3 0 0.02p
Rbc1_23_4 nbc1_23_3 nbc1_23_4 169000.0
Cbc1_23_4 nbc1_23_4 0 0.02p
Rbc1_23_5 nbc1_23_4 b 169000.0
Vbc2 bc2in 0 DC 0 AC -0.5
Rbc2_0_0 bc2in nbc2_0_0 169000.0
Cbc2_0_0 nbc2_0_0 0 0.02p
Rbc2_0_1 nbc2_0_0 nbc2_0_1 169000.0
Cbc2_0_1 nbc2_0_1 0 0.02p
Rbc2_0_2 nbc2_0_1 nbc2_0_2 169000.0
Cbc2_0_2 nbc2_0_2 0 0.02p
Rbc2_0_3 nbc2_0_2 nbc2_0_3 169000.0
Cbc2_0_3 nbc2_0_3 0 0.02p
Rbc2_0_4 nbc2_0_3 nbc2_0_4 169000.0
Cbc2_0_4 nbc2_0_4 0 0.02p
Rbc2_0_5 nbc2_0_4 b 169000.0
Rbc2_1_0 bc2in nbc2_1_0 169000.0
Cbc2_1_0 nbc2_1_0 0 0.02p
Rbc2_1_1 nbc2_1_0 nbc2_1_1 169000.0
Cbc2_1_1 nbc2_1_1 0 0.02p
Rbc2_1_2 nbc2_1_1 nbc2_1_2 169000.0
Cbc2_1_2 nbc2_1_2 0 0.02p
Rbc2_1_3 nbc2_1_2 nbc2_1_3 169000.0
Cbc2_1_3 nbc2_1_3 0 0.02p
Rbc2_1_4 nbc2_1_3 nbc2_1_4 169000.0
Cbc2_1_4 nbc2_1_4 0 0.02p
Rbc2_1_5 nbc2_1_4 b 169000.0
Rbc2_2_0 bc2in nbc2_2_0 169000.0
Cbc2_2_0 nbc2_2_0 0 0.02p
Rbc2_2_1 nbc2_2_0 nbc2_2_1 169000.0
Cbc2_2_1 nbc2_2_1 0 0.02p
Rbc2_2_2 nbc2_2_1 nbc2_2_2 169000.0
Cbc2_2_2 nbc2_2_2 0 0.02p
Rbc2_2_3 nbc2_2_2 nbc2_2_3 169000.0
Cbc2_2_3 nbc2_2_3 0 0.02p
Rbc2_2_4 nbc2_2_3 nbc2_2_4 169000.0
Cbc2_2_4 nbc2_2_4 0 0.02p
Rbc2_2_5 nbc2_2_4 b 169000.0
Rbc2_3_0 bc2in nbc2_3_0 169000.0
Cbc2_3_0 nbc2_3_0 0 0.02p
Rbc2_3_1 nbc2_3_0 nbc2_3_1 169000.0
Cbc2_3_1 nbc2_3_1 0 0.02p
Rbc2_3_2 nbc2_3_1 nbc2_3_2 169000.0
Cbc2_3_2 nbc2_3_2 0 0.02p
Rbc2_3_3 nbc2_3_2 nbc2_3_3 169000.0
Cbc2_3_3 nbc2_3_3 0 0.02p
Rbc2_3_4 nbc2_3_3 nbc2_3_4 169000.0
Cbc2_3_4 nbc2_3_4 0 0.02p
Rbc2_3_5 nbc2_3_4 b 169000.0
Rbc2_4_0 bc2in nbc2_4_0 169000.0
Cbc2_4_0 nbc2_4_0 0 0.02p
Rbc2_4_1 nbc2_4_0 nbc2_4_1 169000.0
Cbc2_4_1 nbc2_4_1 0 0.02p
Rbc2_4_2 nbc2_4_1 nbc2_4_2 169000.0
Cbc2_4_2 nbc2_4_2 0 0.02p
Rbc2_4_3 nbc2_4_2 nbc2_4_3 169000.0
Cbc2_4_3 nbc2_4_3 0 0.02p
Rbc2_4_4 nbc2_4_3 nbc2_4_4 169000.0
Cbc2_4_4 nbc2_4_4 0 0.02p
Rbc2_4_5 nbc2_4_4 b 169000.0
Rbc2_5_0 bc2in nbc2_5_0 169000.0
Cbc2_5_0 nbc2_5_0 0 0.02p
Rbc2_5_1 nbc2_5_0 nbc2_5_1 169000.0
Cbc2_5_1 nbc2_5_1 0 0.02p
Rbc2_5_2 nbc2_5_1 nbc2_5_2 169000.0
Cbc2_5_2 nbc2_5_2 0 0.02p
Rbc2_5_3 nbc2_5_2 nbc2_5_3 169000.0
Cbc2_5_3 nbc2_5_3 0 0.02p
Rbc2_5_4 nbc2_5_3 nbc2_5_4 169000.0
Cbc2_5_4 nbc2_5_4 0 0.02p
Rbc2_5_5 nbc2_5_4 b 169000.0
Rbc2_6_0 bc2in nbc2_6_0 169000.0
Cbc2_6_0 nbc2_6_0 0 0.02p
Rbc2_6_1 nbc2_6_0 nbc2_6_1 169000.0
Cbc2_6_1 nbc2_6_1 0 0.02p
Rbc2_6_2 nbc2_6_1 nbc2_6_2 169000.0
Cbc2_6_2 nbc2_6_2 0 0.02p
Rbc2_6_3 nbc2_6_2 nbc2_6_3 169000.0
Cbc2_6_3 nbc2_6_3 0 0.02p
Rbc2_6_4 nbc2_6_3 nbc2_6_4 169000.0
Cbc2_6_4 nbc2_6_4 0 0.02p
Rbc2_6_5 nbc2_6_4 b 169000.0
Rbc2_7_0 bc2in nbc2_7_0 169000.0
Cbc2_7_0 nbc2_7_0 0 0.02p
Rbc2_7_1 nbc2_7_0 nbc2_7_1 169000.0
Cbc2_7_1 nbc2_7_1 0 0.02p
Rbc2_7_2 nbc2_7_1 nbc2_7_2 169000.0
Cbc2_7_2 nbc2_7_2 0 0.02p
Rbc2_7_3 nbc2_7_2 nbc2_7_3 169000.0
Cbc2_7_3 nbc2_7_3 0 0.02p
Rbc2_7_4 nbc2_7_3 nbc2_7_4 169000.0
Cbc2_7_4 nbc2_7_4 0 0.02p
Rbc2_7_5 nbc2_7_4 b 169000.0
Rbc2_8_0 bc2in nbc2_8_0 169000.0
Cbc2_8_0 nbc2_8_0 0 0.02p
Rbc2_8_1 nbc2_8_0 nbc2_8_1 169000.0
Cbc2_8_1 nbc2_8_1 0 0.02p
Rbc2_8_2 nbc2_8_1 nbc2_8_2 169000.0
Cbc2_8_2 nbc2_8_2 0 0.02p
Rbc2_8_3 nbc2_8_2 nbc2_8_3 169000.0
Cbc2_8_3 nbc2_8_3 0 0.02p
Rbc2_8_4 nbc2_8_3 nbc2_8_4 169000.0
Cbc2_8_4 nbc2_8_4 0 0.02p
Rbc2_8_5 nbc2_8_4 b 169000.0
Rbc2_9_0 bc2in nbc2_9_0 169000.0
Cbc2_9_0 nbc2_9_0 0 0.02p
Rbc2_9_1 nbc2_9_0 nbc2_9_1 169000.0
Cbc2_9_1 nbc2_9_1 0 0.02p
Rbc2_9_2 nbc2_9_1 nbc2_9_2 169000.0
Cbc2_9_2 nbc2_9_2 0 0.02p
Rbc2_9_3 nbc2_9_2 nbc2_9_3 169000.0
Cbc2_9_3 nbc2_9_3 0 0.02p
Rbc2_9_4 nbc2_9_3 nbc2_9_4 169000.0
Cbc2_9_4 nbc2_9_4 0 0.02p
Rbc2_9_5 nbc2_9_4 b 169000.0
Rbc2_10_0 bc2in nbc2_10_0 169000.0
Cbc2_10_0 nbc2_10_0 0 0.02p
Rbc2_10_1 nbc2_10_0 nbc2_10_1 169000.0
Cbc2_10_1 nbc2_10_1 0 0.02p
Rbc2_10_2 nbc2_10_1 nbc2_10_2 169000.0
Cbc2_10_2 nbc2_10_2 0 0.02p
Rbc2_10_3 nbc2_10_2 nbc2_10_3 169000.0
Cbc2_10_3 nbc2_10_3 0 0.02p
Rbc2_10_4 nbc2_10_3 nbc2_10_4 169000.0
Cbc2_10_4 nbc2_10_4 0 0.02p
Rbc2_10_5 nbc2_10_4 b 169000.0
Rbc2_11_0 bc2in nbc2_11_0 169000.0
Cbc2_11_0 nbc2_11_0 0 0.02p
Rbc2_11_1 nbc2_11_0 nbc2_11_1 169000.0
Cbc2_11_1 nbc2_11_1 0 0.02p
Rbc2_11_2 nbc2_11_1 nbc2_11_2 169000.0
Cbc2_11_2 nbc2_11_2 0 0.02p
Rbc2_11_3 nbc2_11_2 nbc2_11_3 169000.0
Cbc2_11_3 nbc2_11_3 0 0.02p
Rbc2_11_4 nbc2_11_3 nbc2_11_4 169000.0
Cbc2_11_4 nbc2_11_4 0 0.02p
Rbc2_11_5 nbc2_11_4 b 169000.0
Rbc2_12_0 bc2in nbc2_12_0 169000.0
Cbc2_12_0 nbc2_12_0 0 0.02p
Rbc2_12_1 nbc2_12_0 nbc2_12_1 169000.0
Cbc2_12_1 nbc2_12_1 0 0.02p
Rbc2_12_2 nbc2_12_1 nbc2_12_2 169000.0
Cbc2_12_2 nbc2_12_2 0 0.02p
Rbc2_12_3 nbc2_12_2 nbc2_12_3 169000.0
Cbc2_12_3 nbc2_12_3 0 0.02p
Rbc2_12_4 nbc2_12_3 nbc2_12_4 169000.0
Cbc2_12_4 nbc2_12_4 0 0.02p
Rbc2_12_5 nbc2_12_4 b 169000.0
Rbc2_13_0 bc2in nbc2_13_0 169000.0
Cbc2_13_0 nbc2_13_0 0 0.02p
Rbc2_13_1 nbc2_13_0 nbc2_13_1 169000.0
Cbc2_13_1 nbc2_13_1 0 0.02p
Rbc2_13_2 nbc2_13_1 nbc2_13_2 169000.0
Cbc2_13_2 nbc2_13_2 0 0.02p
Rbc2_13_3 nbc2_13_2 nbc2_13_3 169000.0
Cbc2_13_3 nbc2_13_3 0 0.02p
Rbc2_13_4 nbc2_13_3 nbc2_13_4 169000.0
Cbc2_13_4 nbc2_13_4 0 0.02p
Rbc2_13_5 nbc2_13_4 b 169000.0
Rbc2_14_0 bc2in nbc2_14_0 169000.0
Cbc2_14_0 nbc2_14_0 0 0.02p
Rbc2_14_1 nbc2_14_0 nbc2_14_1 169000.0
Cbc2_14_1 nbc2_14_1 0 0.02p
Rbc2_14_2 nbc2_14_1 nbc2_14_2 169000.0
Cbc2_14_2 nbc2_14_2 0 0.02p
Rbc2_14_3 nbc2_14_2 nbc2_14_3 169000.0
Cbc2_14_3 nbc2_14_3 0 0.02p
Rbc2_14_4 nbc2_14_3 nbc2_14_4 169000.0
Cbc2_14_4 nbc2_14_4 0 0.02p
Rbc2_14_5 nbc2_14_4 b 169000.0
Rbc2_15_0 bc2in nbc2_15_0 169000.0
Cbc2_15_0 nbc2_15_0 0 0.02p
Rbc2_15_1 nbc2_15_0 nbc2_15_1 169000.0
Cbc2_15_1 nbc2_15_1 0 0.02p
Rbc2_15_2 nbc2_15_1 nbc2_15_2 169000.0
Cbc2_15_2 nbc2_15_2 0 0.02p
Rbc2_15_3 nbc2_15_2 nbc2_15_3 169000.0
Cbc2_15_3 nbc2_15_3 0 0.02p
Rbc2_15_4 nbc2_15_3 nbc2_15_4 169000.0
Cbc2_15_4 nbc2_15_4 0 0.02p
Rbc2_15_5 nbc2_15_4 b 169000.0
Rbc2_16_0 bc2in nbc2_16_0 169000.0
Cbc2_16_0 nbc2_16_0 0 0.02p
Rbc2_16_1 nbc2_16_0 nbc2_16_1 169000.0
Cbc2_16_1 nbc2_16_1 0 0.02p
Rbc2_16_2 nbc2_16_1 nbc2_16_2 169000.0
Cbc2_16_2 nbc2_16_2 0 0.02p
Rbc2_16_3 nbc2_16_2 nbc2_16_3 169000.0
Cbc2_16_3 nbc2_16_3 0 0.02p
Rbc2_16_4 nbc2_16_3 nbc2_16_4 169000.0
Cbc2_16_4 nbc2_16_4 0 0.02p
Rbc2_16_5 nbc2_16_4 b 169000.0
Rbc2_17_0 bc2in nbc2_17_0 169000.0
Cbc2_17_0 nbc2_17_0 0 0.02p
Rbc2_17_1 nbc2_17_0 nbc2_17_1 169000.0
Cbc2_17_1 nbc2_17_1 0 0.02p
Rbc2_17_2 nbc2_17_1 nbc2_17_2 169000.0
Cbc2_17_2 nbc2_17_2 0 0.02p
Rbc2_17_3 nbc2_17_2 nbc2_17_3 169000.0
Cbc2_17_3 nbc2_17_3 0 0.02p
Rbc2_17_4 nbc2_17_3 nbc2_17_4 169000.0
Cbc2_17_4 nbc2_17_4 0 0.02p
Rbc2_17_5 nbc2_17_4 b 169000.0
Rbc2_18_0 bc2in nbc2_18_0 169000.0
Cbc2_18_0 nbc2_18_0 0 0.02p
Rbc2_18_1 nbc2_18_0 nbc2_18_1 169000.0
Cbc2_18_1 nbc2_18_1 0 0.02p
Rbc2_18_2 nbc2_18_1 nbc2_18_2 169000.0
Cbc2_18_2 nbc2_18_2 0 0.02p
Rbc2_18_3 nbc2_18_2 nbc2_18_3 169000.0
Cbc2_18_3 nbc2_18_3 0 0.02p
Rbc2_18_4 nbc2_18_3 nbc2_18_4 169000.0
Cbc2_18_4 nbc2_18_4 0 0.02p
Rbc2_18_5 nbc2_18_4 b 169000.0
Rbc2_19_0 bc2in nbc2_19_0 169000.0
Cbc2_19_0 nbc2_19_0 0 0.02p
Rbc2_19_1 nbc2_19_0 nbc2_19_1 169000.0
Cbc2_19_1 nbc2_19_1 0 0.02p
Rbc2_19_2 nbc2_19_1 nbc2_19_2 169000.0
Cbc2_19_2 nbc2_19_2 0 0.02p
Rbc2_19_3 nbc2_19_2 nbc2_19_3 169000.0
Cbc2_19_3 nbc2_19_3 0 0.02p
Rbc2_19_4 nbc2_19_3 nbc2_19_4 169000.0
Cbc2_19_4 nbc2_19_4 0 0.02p
Rbc2_19_5 nbc2_19_4 b 169000.0
Rbc2_20_0 bc2in nbc2_20_0 169000.0
Cbc2_20_0 nbc2_20_0 0 0.02p
Rbc2_20_1 nbc2_20_0 nbc2_20_1 169000.0
Cbc2_20_1 nbc2_20_1 0 0.02p
Rbc2_20_2 nbc2_20_1 nbc2_20_2 169000.0
Cbc2_20_2 nbc2_20_2 0 0.02p
Rbc2_20_3 nbc2_20_2 nbc2_20_3 169000.0
Cbc2_20_3 nbc2_20_3 0 0.02p
Rbc2_20_4 nbc2_20_3 nbc2_20_4 169000.0
Cbc2_20_4 nbc2_20_4 0 0.02p
Rbc2_20_5 nbc2_20_4 b 169000.0
Rbc2_21_0 bc2in nbc2_21_0 169000.0
Cbc2_21_0 nbc2_21_0 0 0.02p
Rbc2_21_1 nbc2_21_0 nbc2_21_1 169000.0
Cbc2_21_1 nbc2_21_1 0 0.02p
Rbc2_21_2 nbc2_21_1 nbc2_21_2 169000.0
Cbc2_21_2 nbc2_21_2 0 0.02p
Rbc2_21_3 nbc2_21_2 nbc2_21_3 169000.0
Cbc2_21_3 nbc2_21_3 0 0.02p
Rbc2_21_4 nbc2_21_3 nbc2_21_4 169000.0
Cbc2_21_4 nbc2_21_4 0 0.02p
Rbc2_21_5 nbc2_21_4 b 169000.0
Rbc2_22_0 bc2in nbc2_22_0 169000.0
Cbc2_22_0 nbc2_22_0 0 0.02p
Rbc2_22_1 nbc2_22_0 nbc2_22_1 169000.0
Cbc2_22_1 nbc2_22_1 0 0.02p
Rbc2_22_2 nbc2_22_1 nbc2_22_2 169000.0
Cbc2_22_2 nbc2_22_2 0 0.02p
Rbc2_22_3 nbc2_22_2 nbc2_22_3 169000.0
Cbc2_22_3 nbc2_22_3 0 0.02p
Rbc2_22_4 nbc2_22_3 nbc2_22_4 169000.0
Cbc2_22_4 nbc2_22_4 0 0.02p
Rbc2_22_5 nbc2_22_4 b 169000.0
Rbc2_23_0 bc2in nbc2_23_0 169000.0
Cbc2_23_0 nbc2_23_0 0 0.02p
Rbc2_23_1 nbc2_23_0 nbc2_23_1 169000.0
Cbc2_23_1 nbc2_23_1 0 0.02p
Rbc2_23_2 nbc2_23_1 nbc2_23_2 169000.0
Cbc2_23_2 nbc2_23_2 0 0.02p
Rbc2_23_3 nbc2_23_2 nbc2_23_3 169000.0
Cbc2_23_3 nbc2_23_3 0 0.02p
Rbc2_23_4 nbc2_23_3 nbc2_23_4 169000.0
Cbc2_23_4 nbc2_23_4 0 0.02p
Rbc2_23_5 nbc2_23_4 b 169000.0
Vbc3 bc3in 0 DC 0 AC -0.5
Rbc3_0_0 bc3in nbc3_0_0 169000.0
Cbc3_0_0 nbc3_0_0 0 0.02p
Rbc3_0_1 nbc3_0_0 nbc3_0_1 169000.0
Cbc3_0_1 nbc3_0_1 0 0.02p
Rbc3_0_2 nbc3_0_1 nbc3_0_2 169000.0
Cbc3_0_2 nbc3_0_2 0 0.02p
Rbc3_0_3 nbc3_0_2 nbc3_0_3 169000.0
Cbc3_0_3 nbc3_0_3 0 0.02p
Rbc3_0_4 nbc3_0_3 nbc3_0_4 169000.0
Cbc3_0_4 nbc3_0_4 0 0.02p
Rbc3_0_5 nbc3_0_4 b 169000.0
Rbc3_1_0 bc3in nbc3_1_0 169000.0
Cbc3_1_0 nbc3_1_0 0 0.02p
Rbc3_1_1 nbc3_1_0 nbc3_1_1 169000.0
Cbc3_1_1 nbc3_1_1 0 0.02p
Rbc3_1_2 nbc3_1_1 nbc3_1_2 169000.0
Cbc3_1_2 nbc3_1_2 0 0.02p
Rbc3_1_3 nbc3_1_2 nbc3_1_3 169000.0
Cbc3_1_3 nbc3_1_3 0 0.02p
Rbc3_1_4 nbc3_1_3 nbc3_1_4 169000.0
Cbc3_1_4 nbc3_1_4 0 0.02p
Rbc3_1_5 nbc3_1_4 b 169000.0
Rbc3_2_0 bc3in nbc3_2_0 169000.0
Cbc3_2_0 nbc3_2_0 0 0.02p
Rbc3_2_1 nbc3_2_0 nbc3_2_1 169000.0
Cbc3_2_1 nbc3_2_1 0 0.02p
Rbc3_2_2 nbc3_2_1 nbc3_2_2 169000.0
Cbc3_2_2 nbc3_2_2 0 0.02p
Rbc3_2_3 nbc3_2_2 nbc3_2_3 169000.0
Cbc3_2_3 nbc3_2_3 0 0.02p
Rbc3_2_4 nbc3_2_3 nbc3_2_4 169000.0
Cbc3_2_4 nbc3_2_4 0 0.02p
Rbc3_2_5 nbc3_2_4 b 169000.0
Rbc3_3_0 bc3in nbc3_3_0 169000.0
Cbc3_3_0 nbc3_3_0 0 0.02p
Rbc3_3_1 nbc3_3_0 nbc3_3_1 169000.0
Cbc3_3_1 nbc3_3_1 0 0.02p
Rbc3_3_2 nbc3_3_1 nbc3_3_2 169000.0
Cbc3_3_2 nbc3_3_2 0 0.02p
Rbc3_3_3 nbc3_3_2 nbc3_3_3 169000.0
Cbc3_3_3 nbc3_3_3 0 0.02p
Rbc3_3_4 nbc3_3_3 nbc3_3_4 169000.0
Cbc3_3_4 nbc3_3_4 0 0.02p
Rbc3_3_5 nbc3_3_4 b 169000.0
Rbc3_4_0 bc3in nbc3_4_0 169000.0
Cbc3_4_0 nbc3_4_0 0 0.02p
Rbc3_4_1 nbc3_4_0 nbc3_4_1 169000.0
Cbc3_4_1 nbc3_4_1 0 0.02p
Rbc3_4_2 nbc3_4_1 nbc3_4_2 169000.0
Cbc3_4_2 nbc3_4_2 0 0.02p
Rbc3_4_3 nbc3_4_2 nbc3_4_3 169000.0
Cbc3_4_3 nbc3_4_3 0 0.02p
Rbc3_4_4 nbc3_4_3 nbc3_4_4 169000.0
Cbc3_4_4 nbc3_4_4 0 0.02p
Rbc3_4_5 nbc3_4_4 b 169000.0
Rbc3_5_0 bc3in nbc3_5_0 169000.0
Cbc3_5_0 nbc3_5_0 0 0.02p
Rbc3_5_1 nbc3_5_0 nbc3_5_1 169000.0
Cbc3_5_1 nbc3_5_1 0 0.02p
Rbc3_5_2 nbc3_5_1 nbc3_5_2 169000.0
Cbc3_5_2 nbc3_5_2 0 0.02p
Rbc3_5_3 nbc3_5_2 nbc3_5_3 169000.0
Cbc3_5_3 nbc3_5_3 0 0.02p
Rbc3_5_4 nbc3_5_3 nbc3_5_4 169000.0
Cbc3_5_4 nbc3_5_4 0 0.02p
Rbc3_5_5 nbc3_5_4 b 169000.0
Rbc3_6_0 bc3in nbc3_6_0 169000.0
Cbc3_6_0 nbc3_6_0 0 0.02p
Rbc3_6_1 nbc3_6_0 nbc3_6_1 169000.0
Cbc3_6_1 nbc3_6_1 0 0.02p
Rbc3_6_2 nbc3_6_1 nbc3_6_2 169000.0
Cbc3_6_2 nbc3_6_2 0 0.02p
Rbc3_6_3 nbc3_6_2 nbc3_6_3 169000.0
Cbc3_6_3 nbc3_6_3 0 0.02p
Rbc3_6_4 nbc3_6_3 nbc3_6_4 169000.0
Cbc3_6_4 nbc3_6_4 0 0.02p
Rbc3_6_5 nbc3_6_4 b 169000.0
Rbc3_7_0 bc3in nbc3_7_0 169000.0
Cbc3_7_0 nbc3_7_0 0 0.02p
Rbc3_7_1 nbc3_7_0 nbc3_7_1 169000.0
Cbc3_7_1 nbc3_7_1 0 0.02p
Rbc3_7_2 nbc3_7_1 nbc3_7_2 169000.0
Cbc3_7_2 nbc3_7_2 0 0.02p
Rbc3_7_3 nbc3_7_2 nbc3_7_3 169000.0
Cbc3_7_3 nbc3_7_3 0 0.02p
Rbc3_7_4 nbc3_7_3 nbc3_7_4 169000.0
Cbc3_7_4 nbc3_7_4 0 0.02p
Rbc3_7_5 nbc3_7_4 b 169000.0
Rbc3_8_0 bc3in nbc3_8_0 169000.0
Cbc3_8_0 nbc3_8_0 0 0.02p
Rbc3_8_1 nbc3_8_0 nbc3_8_1 169000.0
Cbc3_8_1 nbc3_8_1 0 0.02p
Rbc3_8_2 nbc3_8_1 nbc3_8_2 169000.0
Cbc3_8_2 nbc3_8_2 0 0.02p
Rbc3_8_3 nbc3_8_2 nbc3_8_3 169000.0
Cbc3_8_3 nbc3_8_3 0 0.02p
Rbc3_8_4 nbc3_8_3 nbc3_8_4 169000.0
Cbc3_8_4 nbc3_8_4 0 0.02p
Rbc3_8_5 nbc3_8_4 b 169000.0
Rbc3_9_0 bc3in nbc3_9_0 169000.0
Cbc3_9_0 nbc3_9_0 0 0.02p
Rbc3_9_1 nbc3_9_0 nbc3_9_1 169000.0
Cbc3_9_1 nbc3_9_1 0 0.02p
Rbc3_9_2 nbc3_9_1 nbc3_9_2 169000.0
Cbc3_9_2 nbc3_9_2 0 0.02p
Rbc3_9_3 nbc3_9_2 nbc3_9_3 169000.0
Cbc3_9_3 nbc3_9_3 0 0.02p
Rbc3_9_4 nbc3_9_3 nbc3_9_4 169000.0
Cbc3_9_4 nbc3_9_4 0 0.02p
Rbc3_9_5 nbc3_9_4 b 169000.0
Rbc3_10_0 bc3in nbc3_10_0 169000.0
Cbc3_10_0 nbc3_10_0 0 0.02p
Rbc3_10_1 nbc3_10_0 nbc3_10_1 169000.0
Cbc3_10_1 nbc3_10_1 0 0.02p
Rbc3_10_2 nbc3_10_1 nbc3_10_2 169000.0
Cbc3_10_2 nbc3_10_2 0 0.02p
Rbc3_10_3 nbc3_10_2 nbc3_10_3 169000.0
Cbc3_10_3 nbc3_10_3 0 0.02p
Rbc3_10_4 nbc3_10_3 nbc3_10_4 169000.0
Cbc3_10_4 nbc3_10_4 0 0.02p
Rbc3_10_5 nbc3_10_4 b 169000.0
Rbc3_11_0 bc3in nbc3_11_0 169000.0
Cbc3_11_0 nbc3_11_0 0 0.02p
Rbc3_11_1 nbc3_11_0 nbc3_11_1 169000.0
Cbc3_11_1 nbc3_11_1 0 0.02p
Rbc3_11_2 nbc3_11_1 nbc3_11_2 169000.0
Cbc3_11_2 nbc3_11_2 0 0.02p
Rbc3_11_3 nbc3_11_2 nbc3_11_3 169000.0
Cbc3_11_3 nbc3_11_3 0 0.02p
Rbc3_11_4 nbc3_11_3 nbc3_11_4 169000.0
Cbc3_11_4 nbc3_11_4 0 0.02p
Rbc3_11_5 nbc3_11_4 b 169000.0
Rbc3_12_0 bc3in nbc3_12_0 169000.0
Cbc3_12_0 nbc3_12_0 0 0.02p
Rbc3_12_1 nbc3_12_0 nbc3_12_1 169000.0
Cbc3_12_1 nbc3_12_1 0 0.02p
Rbc3_12_2 nbc3_12_1 nbc3_12_2 169000.0
Cbc3_12_2 nbc3_12_2 0 0.02p
Rbc3_12_3 nbc3_12_2 nbc3_12_3 169000.0
Cbc3_12_3 nbc3_12_3 0 0.02p
Rbc3_12_4 nbc3_12_3 nbc3_12_4 169000.0
Cbc3_12_4 nbc3_12_4 0 0.02p
Rbc3_12_5 nbc3_12_4 b 169000.0
Rbc3_13_0 bc3in nbc3_13_0 169000.0
Cbc3_13_0 nbc3_13_0 0 0.02p
Rbc3_13_1 nbc3_13_0 nbc3_13_1 169000.0
Cbc3_13_1 nbc3_13_1 0 0.02p
Rbc3_13_2 nbc3_13_1 nbc3_13_2 169000.0
Cbc3_13_2 nbc3_13_2 0 0.02p
Rbc3_13_3 nbc3_13_2 nbc3_13_3 169000.0
Cbc3_13_3 nbc3_13_3 0 0.02p
Rbc3_13_4 nbc3_13_3 nbc3_13_4 169000.0
Cbc3_13_4 nbc3_13_4 0 0.02p
Rbc3_13_5 nbc3_13_4 b 169000.0
Rbc3_14_0 bc3in nbc3_14_0 169000.0
Cbc3_14_0 nbc3_14_0 0 0.02p
Rbc3_14_1 nbc3_14_0 nbc3_14_1 169000.0
Cbc3_14_1 nbc3_14_1 0 0.02p
Rbc3_14_2 nbc3_14_1 nbc3_14_2 169000.0
Cbc3_14_2 nbc3_14_2 0 0.02p
Rbc3_14_3 nbc3_14_2 nbc3_14_3 169000.0
Cbc3_14_3 nbc3_14_3 0 0.02p
Rbc3_14_4 nbc3_14_3 nbc3_14_4 169000.0
Cbc3_14_4 nbc3_14_4 0 0.02p
Rbc3_14_5 nbc3_14_4 b 169000.0
Rbc3_15_0 bc3in nbc3_15_0 169000.0
Cbc3_15_0 nbc3_15_0 0 0.02p
Rbc3_15_1 nbc3_15_0 nbc3_15_1 169000.0
Cbc3_15_1 nbc3_15_1 0 0.02p
Rbc3_15_2 nbc3_15_1 nbc3_15_2 169000.0
Cbc3_15_2 nbc3_15_2 0 0.02p
Rbc3_15_3 nbc3_15_2 nbc3_15_3 169000.0
Cbc3_15_3 nbc3_15_3 0 0.02p
Rbc3_15_4 nbc3_15_3 nbc3_15_4 169000.0
Cbc3_15_4 nbc3_15_4 0 0.02p
Rbc3_15_5 nbc3_15_4 b 169000.0
Rbc3_16_0 bc3in nbc3_16_0 169000.0
Cbc3_16_0 nbc3_16_0 0 0.02p
Rbc3_16_1 nbc3_16_0 nbc3_16_1 169000.0
Cbc3_16_1 nbc3_16_1 0 0.02p
Rbc3_16_2 nbc3_16_1 nbc3_16_2 169000.0
Cbc3_16_2 nbc3_16_2 0 0.02p
Rbc3_16_3 nbc3_16_2 nbc3_16_3 169000.0
Cbc3_16_3 nbc3_16_3 0 0.02p
Rbc3_16_4 nbc3_16_3 nbc3_16_4 169000.0
Cbc3_16_4 nbc3_16_4 0 0.02p
Rbc3_16_5 nbc3_16_4 b 169000.0
Rbc3_17_0 bc3in nbc3_17_0 169000.0
Cbc3_17_0 nbc3_17_0 0 0.02p
Rbc3_17_1 nbc3_17_0 nbc3_17_1 169000.0
Cbc3_17_1 nbc3_17_1 0 0.02p
Rbc3_17_2 nbc3_17_1 nbc3_17_2 169000.0
Cbc3_17_2 nbc3_17_2 0 0.02p
Rbc3_17_3 nbc3_17_2 nbc3_17_3 169000.0
Cbc3_17_3 nbc3_17_3 0 0.02p
Rbc3_17_4 nbc3_17_3 nbc3_17_4 169000.0
Cbc3_17_4 nbc3_17_4 0 0.02p
Rbc3_17_5 nbc3_17_4 b 169000.0
Rbc3_18_0 bc3in nbc3_18_0 169000.0
Cbc3_18_0 nbc3_18_0 0 0.02p
Rbc3_18_1 nbc3_18_0 nbc3_18_1 169000.0
Cbc3_18_1 nbc3_18_1 0 0.02p
Rbc3_18_2 nbc3_18_1 nbc3_18_2 169000.0
Cbc3_18_2 nbc3_18_2 0 0.02p
Rbc3_18_3 nbc3_18_2 nbc3_18_3 169000.0
Cbc3_18_3 nbc3_18_3 0 0.02p
Rbc3_18_4 nbc3_18_3 nbc3_18_4 169000.0
Cbc3_18_4 nbc3_18_4 0 0.02p
Rbc3_18_5 nbc3_18_4 b 169000.0
Rbc3_19_0 bc3in nbc3_19_0 169000.0
Cbc3_19_0 nbc3_19_0 0 0.02p
Rbc3_19_1 nbc3_19_0 nbc3_19_1 169000.0
Cbc3_19_1 nbc3_19_1 0 0.02p
Rbc3_19_2 nbc3_19_1 nbc3_19_2 169000.0
Cbc3_19_2 nbc3_19_2 0 0.02p
Rbc3_19_3 nbc3_19_2 nbc3_19_3 169000.0
Cbc3_19_3 nbc3_19_3 0 0.02p
Rbc3_19_4 nbc3_19_3 nbc3_19_4 169000.0
Cbc3_19_4 nbc3_19_4 0 0.02p
Rbc3_19_5 nbc3_19_4 b 169000.0
Rbc3_20_0 bc3in nbc3_20_0 169000.0
Cbc3_20_0 nbc3_20_0 0 0.02p
Rbc3_20_1 nbc3_20_0 nbc3_20_1 169000.0
Cbc3_20_1 nbc3_20_1 0 0.02p
Rbc3_20_2 nbc3_20_1 nbc3_20_2 169000.0
Cbc3_20_2 nbc3_20_2 0 0.02p
Rbc3_20_3 nbc3_20_2 nbc3_20_3 169000.0
Cbc3_20_3 nbc3_20_3 0 0.02p
Rbc3_20_4 nbc3_20_3 nbc3_20_4 169000.0
Cbc3_20_4 nbc3_20_4 0 0.02p
Rbc3_20_5 nbc3_20_4 b 169000.0
Rbc3_21_0 bc3in nbc3_21_0 169000.0
Cbc3_21_0 nbc3_21_0 0 0.02p
Rbc3_21_1 nbc3_21_0 nbc3_21_1 169000.0
Cbc3_21_1 nbc3_21_1 0 0.02p
Rbc3_21_2 nbc3_21_1 nbc3_21_2 169000.0
Cbc3_21_2 nbc3_21_2 0 0.02p
Rbc3_21_3 nbc3_21_2 nbc3_21_3 169000.0
Cbc3_21_3 nbc3_21_3 0 0.02p
Rbc3_21_4 nbc3_21_3 nbc3_21_4 169000.0
Cbc3_21_4 nbc3_21_4 0 0.02p
Rbc3_21_5 nbc3_21_4 b 169000.0
Rbc3_22_0 bc3in nbc3_22_0 169000.0
Cbc3_22_0 nbc3_22_0 0 0.02p
Rbc3_22_1 nbc3_22_0 nbc3_22_1 169000.0
Cbc3_22_1 nbc3_22_1 0 0.02p
Rbc3_22_2 nbc3_22_1 nbc3_22_2 169000.0
Cbc3_22_2 nbc3_22_2 0 0.02p
Rbc3_22_3 nbc3_22_2 nbc3_22_3 169000.0
Cbc3_22_3 nbc3_22_3 0 0.02p
Rbc3_22_4 nbc3_22_3 nbc3_22_4 169000.0
Cbc3_22_4 nbc3_22_4 0 0.02p
Rbc3_22_5 nbc3_22_4 b 169000.0
Rbc3_23_0 bc3in nbc3_23_0 169000.0
Cbc3_23_0 nbc3_23_0 0 0.02p
Rbc3_23_1 nbc3_23_0 nbc3_23_1 169000.0
Cbc3_23_1 nbc3_23_1 0 0.02p
Rbc3_23_2 nbc3_23_1 nbc3_23_2 169000.0
Cbc3_23_2 nbc3_23_2 0 0.02p
Rbc3_23_3 nbc3_23_2 nbc3_23_3 169000.0
Cbc3_23_3 nbc3_23_3 0 0.02p
Rbc3_23_4 nbc3_23_3 nbc3_23_4 169000.0
Cbc3_23_4 nbc3_23_4 0 0.02p
Rbc3_23_5 nbc3_23_4 b 169000.0
Vbc4 bc4in 0 DC 0 AC -0.5
Rbc4_0_0 bc4in nbc4_0_0 169000.0
Cbc4_0_0 nbc4_0_0 0 0.02p
Rbc4_0_1 nbc4_0_0 nbc4_0_1 169000.0
Cbc4_0_1 nbc4_0_1 0 0.02p
Rbc4_0_2 nbc4_0_1 nbc4_0_2 169000.0
Cbc4_0_2 nbc4_0_2 0 0.02p
Rbc4_0_3 nbc4_0_2 nbc4_0_3 169000.0
Cbc4_0_3 nbc4_0_3 0 0.02p
Rbc4_0_4 nbc4_0_3 nbc4_0_4 169000.0
Cbc4_0_4 nbc4_0_4 0 0.02p
Rbc4_0_5 nbc4_0_4 b 169000.0
Rbc4_1_0 bc4in nbc4_1_0 169000.0
Cbc4_1_0 nbc4_1_0 0 0.02p
Rbc4_1_1 nbc4_1_0 nbc4_1_1 169000.0
Cbc4_1_1 nbc4_1_1 0 0.02p
Rbc4_1_2 nbc4_1_1 nbc4_1_2 169000.0
Cbc4_1_2 nbc4_1_2 0 0.02p
Rbc4_1_3 nbc4_1_2 nbc4_1_3 169000.0
Cbc4_1_3 nbc4_1_3 0 0.02p
Rbc4_1_4 nbc4_1_3 nbc4_1_4 169000.0
Cbc4_1_4 nbc4_1_4 0 0.02p
Rbc4_1_5 nbc4_1_4 b 169000.0
Rbc4_2_0 bc4in nbc4_2_0 169000.0
Cbc4_2_0 nbc4_2_0 0 0.02p
Rbc4_2_1 nbc4_2_0 nbc4_2_1 169000.0
Cbc4_2_1 nbc4_2_1 0 0.02p
Rbc4_2_2 nbc4_2_1 nbc4_2_2 169000.0
Cbc4_2_2 nbc4_2_2 0 0.02p
Rbc4_2_3 nbc4_2_2 nbc4_2_3 169000.0
Cbc4_2_3 nbc4_2_3 0 0.02p
Rbc4_2_4 nbc4_2_3 nbc4_2_4 169000.0
Cbc4_2_4 nbc4_2_4 0 0.02p
Rbc4_2_5 nbc4_2_4 b 169000.0
Rbc4_3_0 bc4in nbc4_3_0 169000.0
Cbc4_3_0 nbc4_3_0 0 0.02p
Rbc4_3_1 nbc4_3_0 nbc4_3_1 169000.0
Cbc4_3_1 nbc4_3_1 0 0.02p
Rbc4_3_2 nbc4_3_1 nbc4_3_2 169000.0
Cbc4_3_2 nbc4_3_2 0 0.02p
Rbc4_3_3 nbc4_3_2 nbc4_3_3 169000.0
Cbc4_3_3 nbc4_3_3 0 0.02p
Rbc4_3_4 nbc4_3_3 nbc4_3_4 169000.0
Cbc4_3_4 nbc4_3_4 0 0.02p
Rbc4_3_5 nbc4_3_4 b 169000.0
Rbc4_4_0 bc4in nbc4_4_0 169000.0
Cbc4_4_0 nbc4_4_0 0 0.02p
Rbc4_4_1 nbc4_4_0 nbc4_4_1 169000.0
Cbc4_4_1 nbc4_4_1 0 0.02p
Rbc4_4_2 nbc4_4_1 nbc4_4_2 169000.0
Cbc4_4_2 nbc4_4_2 0 0.02p
Rbc4_4_3 nbc4_4_2 nbc4_4_3 169000.0
Cbc4_4_3 nbc4_4_3 0 0.02p
Rbc4_4_4 nbc4_4_3 nbc4_4_4 169000.0
Cbc4_4_4 nbc4_4_4 0 0.02p
Rbc4_4_5 nbc4_4_4 b 169000.0
Rbc4_5_0 bc4in nbc4_5_0 169000.0
Cbc4_5_0 nbc4_5_0 0 0.02p
Rbc4_5_1 nbc4_5_0 nbc4_5_1 169000.0
Cbc4_5_1 nbc4_5_1 0 0.02p
Rbc4_5_2 nbc4_5_1 nbc4_5_2 169000.0
Cbc4_5_2 nbc4_5_2 0 0.02p
Rbc4_5_3 nbc4_5_2 nbc4_5_3 169000.0
Cbc4_5_3 nbc4_5_3 0 0.02p
Rbc4_5_4 nbc4_5_3 nbc4_5_4 169000.0
Cbc4_5_4 nbc4_5_4 0 0.02p
Rbc4_5_5 nbc4_5_4 b 169000.0
Rbc4_6_0 bc4in nbc4_6_0 169000.0
Cbc4_6_0 nbc4_6_0 0 0.02p
Rbc4_6_1 nbc4_6_0 nbc4_6_1 169000.0
Cbc4_6_1 nbc4_6_1 0 0.02p
Rbc4_6_2 nbc4_6_1 nbc4_6_2 169000.0
Cbc4_6_2 nbc4_6_2 0 0.02p
Rbc4_6_3 nbc4_6_2 nbc4_6_3 169000.0
Cbc4_6_3 nbc4_6_3 0 0.02p
Rbc4_6_4 nbc4_6_3 nbc4_6_4 169000.0
Cbc4_6_4 nbc4_6_4 0 0.02p
Rbc4_6_5 nbc4_6_4 b 169000.0
Rbc4_7_0 bc4in nbc4_7_0 169000.0
Cbc4_7_0 nbc4_7_0 0 0.02p
Rbc4_7_1 nbc4_7_0 nbc4_7_1 169000.0
Cbc4_7_1 nbc4_7_1 0 0.02p
Rbc4_7_2 nbc4_7_1 nbc4_7_2 169000.0
Cbc4_7_2 nbc4_7_2 0 0.02p
Rbc4_7_3 nbc4_7_2 nbc4_7_3 169000.0
Cbc4_7_3 nbc4_7_3 0 0.02p
Rbc4_7_4 nbc4_7_3 nbc4_7_4 169000.0
Cbc4_7_4 nbc4_7_4 0 0.02p
Rbc4_7_5 nbc4_7_4 b 169000.0
Rbc4_8_0 bc4in nbc4_8_0 169000.0
Cbc4_8_0 nbc4_8_0 0 0.02p
Rbc4_8_1 nbc4_8_0 nbc4_8_1 169000.0
Cbc4_8_1 nbc4_8_1 0 0.02p
Rbc4_8_2 nbc4_8_1 nbc4_8_2 169000.0
Cbc4_8_2 nbc4_8_2 0 0.02p
Rbc4_8_3 nbc4_8_2 nbc4_8_3 169000.0
Cbc4_8_3 nbc4_8_3 0 0.02p
Rbc4_8_4 nbc4_8_3 nbc4_8_4 169000.0
Cbc4_8_4 nbc4_8_4 0 0.02p
Rbc4_8_5 nbc4_8_4 b 169000.0
Rbc4_9_0 bc4in nbc4_9_0 169000.0
Cbc4_9_0 nbc4_9_0 0 0.02p
Rbc4_9_1 nbc4_9_0 nbc4_9_1 169000.0
Cbc4_9_1 nbc4_9_1 0 0.02p
Rbc4_9_2 nbc4_9_1 nbc4_9_2 169000.0
Cbc4_9_2 nbc4_9_2 0 0.02p
Rbc4_9_3 nbc4_9_2 nbc4_9_3 169000.0
Cbc4_9_3 nbc4_9_3 0 0.02p
Rbc4_9_4 nbc4_9_3 nbc4_9_4 169000.0
Cbc4_9_4 nbc4_9_4 0 0.02p
Rbc4_9_5 nbc4_9_4 b 169000.0
Rbc4_10_0 bc4in nbc4_10_0 169000.0
Cbc4_10_0 nbc4_10_0 0 0.02p
Rbc4_10_1 nbc4_10_0 nbc4_10_1 169000.0
Cbc4_10_1 nbc4_10_1 0 0.02p
Rbc4_10_2 nbc4_10_1 nbc4_10_2 169000.0
Cbc4_10_2 nbc4_10_2 0 0.02p
Rbc4_10_3 nbc4_10_2 nbc4_10_3 169000.0
Cbc4_10_3 nbc4_10_3 0 0.02p
Rbc4_10_4 nbc4_10_3 nbc4_10_4 169000.0
Cbc4_10_4 nbc4_10_4 0 0.02p
Rbc4_10_5 nbc4_10_4 b 169000.0
Rbc4_11_0 bc4in nbc4_11_0 169000.0
Cbc4_11_0 nbc4_11_0 0 0.02p
Rbc4_11_1 nbc4_11_0 nbc4_11_1 169000.0
Cbc4_11_1 nbc4_11_1 0 0.02p
Rbc4_11_2 nbc4_11_1 nbc4_11_2 169000.0
Cbc4_11_2 nbc4_11_2 0 0.02p
Rbc4_11_3 nbc4_11_2 nbc4_11_3 169000.0
Cbc4_11_3 nbc4_11_3 0 0.02p
Rbc4_11_4 nbc4_11_3 nbc4_11_4 169000.0
Cbc4_11_4 nbc4_11_4 0 0.02p
Rbc4_11_5 nbc4_11_4 b 169000.0
Rbc4_12_0 bc4in nbc4_12_0 169000.0
Cbc4_12_0 nbc4_12_0 0 0.02p
Rbc4_12_1 nbc4_12_0 nbc4_12_1 169000.0
Cbc4_12_1 nbc4_12_1 0 0.02p
Rbc4_12_2 nbc4_12_1 nbc4_12_2 169000.0
Cbc4_12_2 nbc4_12_2 0 0.02p
Rbc4_12_3 nbc4_12_2 nbc4_12_3 169000.0
Cbc4_12_3 nbc4_12_3 0 0.02p
Rbc4_12_4 nbc4_12_3 nbc4_12_4 169000.0
Cbc4_12_4 nbc4_12_4 0 0.02p
Rbc4_12_5 nbc4_12_4 b 169000.0
Rbc4_13_0 bc4in nbc4_13_0 169000.0
Cbc4_13_0 nbc4_13_0 0 0.02p
Rbc4_13_1 nbc4_13_0 nbc4_13_1 169000.0
Cbc4_13_1 nbc4_13_1 0 0.02p
Rbc4_13_2 nbc4_13_1 nbc4_13_2 169000.0
Cbc4_13_2 nbc4_13_2 0 0.02p
Rbc4_13_3 nbc4_13_2 nbc4_13_3 169000.0
Cbc4_13_3 nbc4_13_3 0 0.02p
Rbc4_13_4 nbc4_13_3 nbc4_13_4 169000.0
Cbc4_13_4 nbc4_13_4 0 0.02p
Rbc4_13_5 nbc4_13_4 b 169000.0
Rbc4_14_0 bc4in nbc4_14_0 169000.0
Cbc4_14_0 nbc4_14_0 0 0.02p
Rbc4_14_1 nbc4_14_0 nbc4_14_1 169000.0
Cbc4_14_1 nbc4_14_1 0 0.02p
Rbc4_14_2 nbc4_14_1 nbc4_14_2 169000.0
Cbc4_14_2 nbc4_14_2 0 0.02p
Rbc4_14_3 nbc4_14_2 nbc4_14_3 169000.0
Cbc4_14_3 nbc4_14_3 0 0.02p
Rbc4_14_4 nbc4_14_3 nbc4_14_4 169000.0
Cbc4_14_4 nbc4_14_4 0 0.02p
Rbc4_14_5 nbc4_14_4 b 169000.0
Rbc4_15_0 bc4in nbc4_15_0 169000.0
Cbc4_15_0 nbc4_15_0 0 0.02p
Rbc4_15_1 nbc4_15_0 nbc4_15_1 169000.0
Cbc4_15_1 nbc4_15_1 0 0.02p
Rbc4_15_2 nbc4_15_1 nbc4_15_2 169000.0
Cbc4_15_2 nbc4_15_2 0 0.02p
Rbc4_15_3 nbc4_15_2 nbc4_15_3 169000.0
Cbc4_15_3 nbc4_15_3 0 0.02p
Rbc4_15_4 nbc4_15_3 nbc4_15_4 169000.0
Cbc4_15_4 nbc4_15_4 0 0.02p
Rbc4_15_5 nbc4_15_4 b 169000.0
Rbc4_16_0 bc4in nbc4_16_0 169000.0
Cbc4_16_0 nbc4_16_0 0 0.02p
Rbc4_16_1 nbc4_16_0 nbc4_16_1 169000.0
Cbc4_16_1 nbc4_16_1 0 0.02p
Rbc4_16_2 nbc4_16_1 nbc4_16_2 169000.0
Cbc4_16_2 nbc4_16_2 0 0.02p
Rbc4_16_3 nbc4_16_2 nbc4_16_3 169000.0
Cbc4_16_3 nbc4_16_3 0 0.02p
Rbc4_16_4 nbc4_16_3 nbc4_16_4 169000.0
Cbc4_16_4 nbc4_16_4 0 0.02p
Rbc4_16_5 nbc4_16_4 b 169000.0
Rbc4_17_0 bc4in nbc4_17_0 169000.0
Cbc4_17_0 nbc4_17_0 0 0.02p
Rbc4_17_1 nbc4_17_0 nbc4_17_1 169000.0
Cbc4_17_1 nbc4_17_1 0 0.02p
Rbc4_17_2 nbc4_17_1 nbc4_17_2 169000.0
Cbc4_17_2 nbc4_17_2 0 0.02p
Rbc4_17_3 nbc4_17_2 nbc4_17_3 169000.0
Cbc4_17_3 nbc4_17_3 0 0.02p
Rbc4_17_4 nbc4_17_3 nbc4_17_4 169000.0
Cbc4_17_4 nbc4_17_4 0 0.02p
Rbc4_17_5 nbc4_17_4 b 169000.0
Rbc4_18_0 bc4in nbc4_18_0 169000.0
Cbc4_18_0 nbc4_18_0 0 0.02p
Rbc4_18_1 nbc4_18_0 nbc4_18_1 169000.0
Cbc4_18_1 nbc4_18_1 0 0.02p
Rbc4_18_2 nbc4_18_1 nbc4_18_2 169000.0
Cbc4_18_2 nbc4_18_2 0 0.02p
Rbc4_18_3 nbc4_18_2 nbc4_18_3 169000.0
Cbc4_18_3 nbc4_18_3 0 0.02p
Rbc4_18_4 nbc4_18_3 nbc4_18_4 169000.0
Cbc4_18_4 nbc4_18_4 0 0.02p
Rbc4_18_5 nbc4_18_4 b 169000.0
Rbc4_19_0 bc4in nbc4_19_0 169000.0
Cbc4_19_0 nbc4_19_0 0 0.02p
Rbc4_19_1 nbc4_19_0 nbc4_19_1 169000.0
Cbc4_19_1 nbc4_19_1 0 0.02p
Rbc4_19_2 nbc4_19_1 nbc4_19_2 169000.0
Cbc4_19_2 nbc4_19_2 0 0.02p
Rbc4_19_3 nbc4_19_2 nbc4_19_3 169000.0
Cbc4_19_3 nbc4_19_3 0 0.02p
Rbc4_19_4 nbc4_19_3 nbc4_19_4 169000.0
Cbc4_19_4 nbc4_19_4 0 0.02p
Rbc4_19_5 nbc4_19_4 b 169000.0
Rbc4_20_0 bc4in nbc4_20_0 169000.0
Cbc4_20_0 nbc4_20_0 0 0.02p
Rbc4_20_1 nbc4_20_0 nbc4_20_1 169000.0
Cbc4_20_1 nbc4_20_1 0 0.02p
Rbc4_20_2 nbc4_20_1 nbc4_20_2 169000.0
Cbc4_20_2 nbc4_20_2 0 0.02p
Rbc4_20_3 nbc4_20_2 nbc4_20_3 169000.0
Cbc4_20_3 nbc4_20_3 0 0.02p
Rbc4_20_4 nbc4_20_3 nbc4_20_4 169000.0
Cbc4_20_4 nbc4_20_4 0 0.02p
Rbc4_20_5 nbc4_20_4 b 169000.0
Rbc4_21_0 bc4in nbc4_21_0 169000.0
Cbc4_21_0 nbc4_21_0 0 0.02p
Rbc4_21_1 nbc4_21_0 nbc4_21_1 169000.0
Cbc4_21_1 nbc4_21_1 0 0.02p
Rbc4_21_2 nbc4_21_1 nbc4_21_2 169000.0
Cbc4_21_2 nbc4_21_2 0 0.02p
Rbc4_21_3 nbc4_21_2 nbc4_21_3 169000.0
Cbc4_21_3 nbc4_21_3 0 0.02p
Rbc4_21_4 nbc4_21_3 nbc4_21_4 169000.0
Cbc4_21_4 nbc4_21_4 0 0.02p
Rbc4_21_5 nbc4_21_4 b 169000.0
Rbc4_22_0 bc4in nbc4_22_0 169000.0
Cbc4_22_0 nbc4_22_0 0 0.02p
Rbc4_22_1 nbc4_22_0 nbc4_22_1 169000.0
Cbc4_22_1 nbc4_22_1 0 0.02p
Rbc4_22_2 nbc4_22_1 nbc4_22_2 169000.0
Cbc4_22_2 nbc4_22_2 0 0.02p
Rbc4_22_3 nbc4_22_2 nbc4_22_3 169000.0
Cbc4_22_3 nbc4_22_3 0 0.02p
Rbc4_22_4 nbc4_22_3 nbc4_22_4 169000.0
Cbc4_22_4 nbc4_22_4 0 0.02p
Rbc4_22_5 nbc4_22_4 b 169000.0
Rbc4_23_0 bc4in nbc4_23_0 169000.0
Cbc4_23_0 nbc4_23_0 0 0.02p
Rbc4_23_1 nbc4_23_0 nbc4_23_1 169000.0
Cbc4_23_1 nbc4_23_1 0 0.02p
Rbc4_23_2 nbc4_23_1 nbc4_23_2 169000.0
Cbc4_23_2 nbc4_23_2 0 0.02p
Rbc4_23_3 nbc4_23_2 nbc4_23_3 169000.0
Cbc4_23_3 nbc4_23_3 0 0.02p
Rbc4_23_4 nbc4_23_3 nbc4_23_4 169000.0
Cbc4_23_4 nbc4_23_4 0 0.02p
Rbc4_23_5 nbc4_23_4 b 169000.0
Vbc5 bc5in 0 DC 0 AC -0.5
Rbc5_0_0 bc5in nbc5_0_0 169000.0
Cbc5_0_0 nbc5_0_0 0 0.02p
Rbc5_0_1 nbc5_0_0 nbc5_0_1 169000.0
Cbc5_0_1 nbc5_0_1 0 0.02p
Rbc5_0_2 nbc5_0_1 nbc5_0_2 169000.0
Cbc5_0_2 nbc5_0_2 0 0.02p
Rbc5_0_3 nbc5_0_2 nbc5_0_3 169000.0
Cbc5_0_3 nbc5_0_3 0 0.02p
Rbc5_0_4 nbc5_0_3 nbc5_0_4 169000.0
Cbc5_0_4 nbc5_0_4 0 0.02p
Rbc5_0_5 nbc5_0_4 b 169000.0
Rbc5_1_0 bc5in nbc5_1_0 169000.0
Cbc5_1_0 nbc5_1_0 0 0.02p
Rbc5_1_1 nbc5_1_0 nbc5_1_1 169000.0
Cbc5_1_1 nbc5_1_1 0 0.02p
Rbc5_1_2 nbc5_1_1 nbc5_1_2 169000.0
Cbc5_1_2 nbc5_1_2 0 0.02p
Rbc5_1_3 nbc5_1_2 nbc5_1_3 169000.0
Cbc5_1_3 nbc5_1_3 0 0.02p
Rbc5_1_4 nbc5_1_3 nbc5_1_4 169000.0
Cbc5_1_4 nbc5_1_4 0 0.02p
Rbc5_1_5 nbc5_1_4 b 169000.0
Rbc5_2_0 bc5in nbc5_2_0 169000.0
Cbc5_2_0 nbc5_2_0 0 0.02p
Rbc5_2_1 nbc5_2_0 nbc5_2_1 169000.0
Cbc5_2_1 nbc5_2_1 0 0.02p
Rbc5_2_2 nbc5_2_1 nbc5_2_2 169000.0
Cbc5_2_2 nbc5_2_2 0 0.02p
Rbc5_2_3 nbc5_2_2 nbc5_2_3 169000.0
Cbc5_2_3 nbc5_2_3 0 0.02p
Rbc5_2_4 nbc5_2_3 nbc5_2_4 169000.0
Cbc5_2_4 nbc5_2_4 0 0.02p
Rbc5_2_5 nbc5_2_4 b 169000.0
Rbc5_3_0 bc5in nbc5_3_0 169000.0
Cbc5_3_0 nbc5_3_0 0 0.02p
Rbc5_3_1 nbc5_3_0 nbc5_3_1 169000.0
Cbc5_3_1 nbc5_3_1 0 0.02p
Rbc5_3_2 nbc5_3_1 nbc5_3_2 169000.0
Cbc5_3_2 nbc5_3_2 0 0.02p
Rbc5_3_3 nbc5_3_2 nbc5_3_3 169000.0
Cbc5_3_3 nbc5_3_3 0 0.02p
Rbc5_3_4 nbc5_3_3 nbc5_3_4 169000.0
Cbc5_3_4 nbc5_3_4 0 0.02p
Rbc5_3_5 nbc5_3_4 b 169000.0
Rbc5_4_0 bc5in nbc5_4_0 169000.0
Cbc5_4_0 nbc5_4_0 0 0.02p
Rbc5_4_1 nbc5_4_0 nbc5_4_1 169000.0
Cbc5_4_1 nbc5_4_1 0 0.02p
Rbc5_4_2 nbc5_4_1 nbc5_4_2 169000.0
Cbc5_4_2 nbc5_4_2 0 0.02p
Rbc5_4_3 nbc5_4_2 nbc5_4_3 169000.0
Cbc5_4_3 nbc5_4_3 0 0.02p
Rbc5_4_4 nbc5_4_3 nbc5_4_4 169000.0
Cbc5_4_4 nbc5_4_4 0 0.02p
Rbc5_4_5 nbc5_4_4 b 169000.0
Rbc5_5_0 bc5in nbc5_5_0 169000.0
Cbc5_5_0 nbc5_5_0 0 0.02p
Rbc5_5_1 nbc5_5_0 nbc5_5_1 169000.0
Cbc5_5_1 nbc5_5_1 0 0.02p
Rbc5_5_2 nbc5_5_1 nbc5_5_2 169000.0
Cbc5_5_2 nbc5_5_2 0 0.02p
Rbc5_5_3 nbc5_5_2 nbc5_5_3 169000.0
Cbc5_5_3 nbc5_5_3 0 0.02p
Rbc5_5_4 nbc5_5_3 nbc5_5_4 169000.0
Cbc5_5_4 nbc5_5_4 0 0.02p
Rbc5_5_5 nbc5_5_4 b 169000.0
Rbc5_6_0 bc5in nbc5_6_0 169000.0
Cbc5_6_0 nbc5_6_0 0 0.02p
Rbc5_6_1 nbc5_6_0 nbc5_6_1 169000.0
Cbc5_6_1 nbc5_6_1 0 0.02p
Rbc5_6_2 nbc5_6_1 nbc5_6_2 169000.0
Cbc5_6_2 nbc5_6_2 0 0.02p
Rbc5_6_3 nbc5_6_2 nbc5_6_3 169000.0
Cbc5_6_3 nbc5_6_3 0 0.02p
Rbc5_6_4 nbc5_6_3 nbc5_6_4 169000.0
Cbc5_6_4 nbc5_6_4 0 0.02p
Rbc5_6_5 nbc5_6_4 b 169000.0
Rbc5_7_0 bc5in nbc5_7_0 169000.0
Cbc5_7_0 nbc5_7_0 0 0.02p
Rbc5_7_1 nbc5_7_0 nbc5_7_1 169000.0
Cbc5_7_1 nbc5_7_1 0 0.02p
Rbc5_7_2 nbc5_7_1 nbc5_7_2 169000.0
Cbc5_7_2 nbc5_7_2 0 0.02p
Rbc5_7_3 nbc5_7_2 nbc5_7_3 169000.0
Cbc5_7_3 nbc5_7_3 0 0.02p
Rbc5_7_4 nbc5_7_3 nbc5_7_4 169000.0
Cbc5_7_4 nbc5_7_4 0 0.02p
Rbc5_7_5 nbc5_7_4 b 169000.0
Rbc5_8_0 bc5in nbc5_8_0 169000.0
Cbc5_8_0 nbc5_8_0 0 0.02p
Rbc5_8_1 nbc5_8_0 nbc5_8_1 169000.0
Cbc5_8_1 nbc5_8_1 0 0.02p
Rbc5_8_2 nbc5_8_1 nbc5_8_2 169000.0
Cbc5_8_2 nbc5_8_2 0 0.02p
Rbc5_8_3 nbc5_8_2 nbc5_8_3 169000.0
Cbc5_8_3 nbc5_8_3 0 0.02p
Rbc5_8_4 nbc5_8_3 nbc5_8_4 169000.0
Cbc5_8_4 nbc5_8_4 0 0.02p
Rbc5_8_5 nbc5_8_4 b 169000.0
Rbc5_9_0 bc5in nbc5_9_0 169000.0
Cbc5_9_0 nbc5_9_0 0 0.02p
Rbc5_9_1 nbc5_9_0 nbc5_9_1 169000.0
Cbc5_9_1 nbc5_9_1 0 0.02p
Rbc5_9_2 nbc5_9_1 nbc5_9_2 169000.0
Cbc5_9_2 nbc5_9_2 0 0.02p
Rbc5_9_3 nbc5_9_2 nbc5_9_3 169000.0
Cbc5_9_3 nbc5_9_3 0 0.02p
Rbc5_9_4 nbc5_9_3 nbc5_9_4 169000.0
Cbc5_9_4 nbc5_9_4 0 0.02p
Rbc5_9_5 nbc5_9_4 b 169000.0
Rbc5_10_0 bc5in nbc5_10_0 169000.0
Cbc5_10_0 nbc5_10_0 0 0.02p
Rbc5_10_1 nbc5_10_0 nbc5_10_1 169000.0
Cbc5_10_1 nbc5_10_1 0 0.02p
Rbc5_10_2 nbc5_10_1 nbc5_10_2 169000.0
Cbc5_10_2 nbc5_10_2 0 0.02p
Rbc5_10_3 nbc5_10_2 nbc5_10_3 169000.0
Cbc5_10_3 nbc5_10_3 0 0.02p
Rbc5_10_4 nbc5_10_3 nbc5_10_4 169000.0
Cbc5_10_4 nbc5_10_4 0 0.02p
Rbc5_10_5 nbc5_10_4 b 169000.0
Rbc5_11_0 bc5in nbc5_11_0 169000.0
Cbc5_11_0 nbc5_11_0 0 0.02p
Rbc5_11_1 nbc5_11_0 nbc5_11_1 169000.0
Cbc5_11_1 nbc5_11_1 0 0.02p
Rbc5_11_2 nbc5_11_1 nbc5_11_2 169000.0
Cbc5_11_2 nbc5_11_2 0 0.02p
Rbc5_11_3 nbc5_11_2 nbc5_11_3 169000.0
Cbc5_11_3 nbc5_11_3 0 0.02p
Rbc5_11_4 nbc5_11_3 nbc5_11_4 169000.0
Cbc5_11_4 nbc5_11_4 0 0.02p
Rbc5_11_5 nbc5_11_4 b 169000.0
Rbc5_12_0 bc5in nbc5_12_0 169000.0
Cbc5_12_0 nbc5_12_0 0 0.02p
Rbc5_12_1 nbc5_12_0 nbc5_12_1 169000.0
Cbc5_12_1 nbc5_12_1 0 0.02p
Rbc5_12_2 nbc5_12_1 nbc5_12_2 169000.0
Cbc5_12_2 nbc5_12_2 0 0.02p
Rbc5_12_3 nbc5_12_2 nbc5_12_3 169000.0
Cbc5_12_3 nbc5_12_3 0 0.02p
Rbc5_12_4 nbc5_12_3 nbc5_12_4 169000.0
Cbc5_12_4 nbc5_12_4 0 0.02p
Rbc5_12_5 nbc5_12_4 b 169000.0
Rbc5_13_0 bc5in nbc5_13_0 169000.0
Cbc5_13_0 nbc5_13_0 0 0.02p
Rbc5_13_1 nbc5_13_0 nbc5_13_1 169000.0
Cbc5_13_1 nbc5_13_1 0 0.02p
Rbc5_13_2 nbc5_13_1 nbc5_13_2 169000.0
Cbc5_13_2 nbc5_13_2 0 0.02p
Rbc5_13_3 nbc5_13_2 nbc5_13_3 169000.0
Cbc5_13_3 nbc5_13_3 0 0.02p
Rbc5_13_4 nbc5_13_3 nbc5_13_4 169000.0
Cbc5_13_4 nbc5_13_4 0 0.02p
Rbc5_13_5 nbc5_13_4 b 169000.0
Rbc5_14_0 bc5in nbc5_14_0 169000.0
Cbc5_14_0 nbc5_14_0 0 0.02p
Rbc5_14_1 nbc5_14_0 nbc5_14_1 169000.0
Cbc5_14_1 nbc5_14_1 0 0.02p
Rbc5_14_2 nbc5_14_1 nbc5_14_2 169000.0
Cbc5_14_2 nbc5_14_2 0 0.02p
Rbc5_14_3 nbc5_14_2 nbc5_14_3 169000.0
Cbc5_14_3 nbc5_14_3 0 0.02p
Rbc5_14_4 nbc5_14_3 nbc5_14_4 169000.0
Cbc5_14_4 nbc5_14_4 0 0.02p
Rbc5_14_5 nbc5_14_4 b 169000.0
Rbc5_15_0 bc5in nbc5_15_0 169000.0
Cbc5_15_0 nbc5_15_0 0 0.02p
Rbc5_15_1 nbc5_15_0 nbc5_15_1 169000.0
Cbc5_15_1 nbc5_15_1 0 0.02p
Rbc5_15_2 nbc5_15_1 nbc5_15_2 169000.0
Cbc5_15_2 nbc5_15_2 0 0.02p
Rbc5_15_3 nbc5_15_2 nbc5_15_3 169000.0
Cbc5_15_3 nbc5_15_3 0 0.02p
Rbc5_15_4 nbc5_15_3 nbc5_15_4 169000.0
Cbc5_15_4 nbc5_15_4 0 0.02p
Rbc5_15_5 nbc5_15_4 b 169000.0
Rbc5_16_0 bc5in nbc5_16_0 169000.0
Cbc5_16_0 nbc5_16_0 0 0.02p
Rbc5_16_1 nbc5_16_0 nbc5_16_1 169000.0
Cbc5_16_1 nbc5_16_1 0 0.02p
Rbc5_16_2 nbc5_16_1 nbc5_16_2 169000.0
Cbc5_16_2 nbc5_16_2 0 0.02p
Rbc5_16_3 nbc5_16_2 nbc5_16_3 169000.0
Cbc5_16_3 nbc5_16_3 0 0.02p
Rbc5_16_4 nbc5_16_3 nbc5_16_4 169000.0
Cbc5_16_4 nbc5_16_4 0 0.02p
Rbc5_16_5 nbc5_16_4 b 169000.0
Rbc5_17_0 bc5in nbc5_17_0 169000.0
Cbc5_17_0 nbc5_17_0 0 0.02p
Rbc5_17_1 nbc5_17_0 nbc5_17_1 169000.0
Cbc5_17_1 nbc5_17_1 0 0.02p
Rbc5_17_2 nbc5_17_1 nbc5_17_2 169000.0
Cbc5_17_2 nbc5_17_2 0 0.02p
Rbc5_17_3 nbc5_17_2 nbc5_17_3 169000.0
Cbc5_17_3 nbc5_17_3 0 0.02p
Rbc5_17_4 nbc5_17_3 nbc5_17_4 169000.0
Cbc5_17_4 nbc5_17_4 0 0.02p
Rbc5_17_5 nbc5_17_4 b 169000.0
Rbc5_18_0 bc5in nbc5_18_0 169000.0
Cbc5_18_0 nbc5_18_0 0 0.02p
Rbc5_18_1 nbc5_18_0 nbc5_18_1 169000.0
Cbc5_18_1 nbc5_18_1 0 0.02p
Rbc5_18_2 nbc5_18_1 nbc5_18_2 169000.0
Cbc5_18_2 nbc5_18_2 0 0.02p
Rbc5_18_3 nbc5_18_2 nbc5_18_3 169000.0
Cbc5_18_3 nbc5_18_3 0 0.02p
Rbc5_18_4 nbc5_18_3 nbc5_18_4 169000.0
Cbc5_18_4 nbc5_18_4 0 0.02p
Rbc5_18_5 nbc5_18_4 b 169000.0
Rbc5_19_0 bc5in nbc5_19_0 169000.0
Cbc5_19_0 nbc5_19_0 0 0.02p
Rbc5_19_1 nbc5_19_0 nbc5_19_1 169000.0
Cbc5_19_1 nbc5_19_1 0 0.02p
Rbc5_19_2 nbc5_19_1 nbc5_19_2 169000.0
Cbc5_19_2 nbc5_19_2 0 0.02p
Rbc5_19_3 nbc5_19_2 nbc5_19_3 169000.0
Cbc5_19_3 nbc5_19_3 0 0.02p
Rbc5_19_4 nbc5_19_3 nbc5_19_4 169000.0
Cbc5_19_4 nbc5_19_4 0 0.02p
Rbc5_19_5 nbc5_19_4 b 169000.0
Rbc5_20_0 bc5in nbc5_20_0 169000.0
Cbc5_20_0 nbc5_20_0 0 0.02p
Rbc5_20_1 nbc5_20_0 nbc5_20_1 169000.0
Cbc5_20_1 nbc5_20_1 0 0.02p
Rbc5_20_2 nbc5_20_1 nbc5_20_2 169000.0
Cbc5_20_2 nbc5_20_2 0 0.02p
Rbc5_20_3 nbc5_20_2 nbc5_20_3 169000.0
Cbc5_20_3 nbc5_20_3 0 0.02p
Rbc5_20_4 nbc5_20_3 nbc5_20_4 169000.0
Cbc5_20_4 nbc5_20_4 0 0.02p
Rbc5_20_5 nbc5_20_4 b 169000.0
Rbc5_21_0 bc5in nbc5_21_0 169000.0
Cbc5_21_0 nbc5_21_0 0 0.02p
Rbc5_21_1 nbc5_21_0 nbc5_21_1 169000.0
Cbc5_21_1 nbc5_21_1 0 0.02p
Rbc5_21_2 nbc5_21_1 nbc5_21_2 169000.0
Cbc5_21_2 nbc5_21_2 0 0.02p
Rbc5_21_3 nbc5_21_2 nbc5_21_3 169000.0
Cbc5_21_3 nbc5_21_3 0 0.02p
Rbc5_21_4 nbc5_21_3 nbc5_21_4 169000.0
Cbc5_21_4 nbc5_21_4 0 0.02p
Rbc5_21_5 nbc5_21_4 b 169000.0
Rbc5_22_0 bc5in nbc5_22_0 169000.0
Cbc5_22_0 nbc5_22_0 0 0.02p
Rbc5_22_1 nbc5_22_0 nbc5_22_1 169000.0
Cbc5_22_1 nbc5_22_1 0 0.02p
Rbc5_22_2 nbc5_22_1 nbc5_22_2 169000.0
Cbc5_22_2 nbc5_22_2 0 0.02p
Rbc5_22_3 nbc5_22_2 nbc5_22_3 169000.0
Cbc5_22_3 nbc5_22_3 0 0.02p
Rbc5_22_4 nbc5_22_3 nbc5_22_4 169000.0
Cbc5_22_4 nbc5_22_4 0 0.02p
Rbc5_22_5 nbc5_22_4 b 169000.0
Rbc5_23_0 bc5in nbc5_23_0 169000.0
Cbc5_23_0 nbc5_23_0 0 0.02p
Rbc5_23_1 nbc5_23_0 nbc5_23_1 169000.0
Cbc5_23_1 nbc5_23_1 0 0.02p
Rbc5_23_2 nbc5_23_1 nbc5_23_2 169000.0
Cbc5_23_2 nbc5_23_2 0 0.02p
Rbc5_23_3 nbc5_23_2 nbc5_23_3 169000.0
Cbc5_23_3 nbc5_23_3 0 0.02p
Rbc5_23_4 nbc5_23_3 nbc5_23_4 169000.0
Cbc5_23_4 nbc5_23_4 0 0.02p
Rbc5_23_5 nbc5_23_4 b 169000.0
Vbc6 bc6in 0 DC 0 AC -0.5
Rbc6_0_0 bc6in nbc6_0_0 169000.0
Cbc6_0_0 nbc6_0_0 0 0.02p
Rbc6_0_1 nbc6_0_0 nbc6_0_1 169000.0
Cbc6_0_1 nbc6_0_1 0 0.02p
Rbc6_0_2 nbc6_0_1 nbc6_0_2 169000.0
Cbc6_0_2 nbc6_0_2 0 0.02p
Rbc6_0_3 nbc6_0_2 nbc6_0_3 169000.0
Cbc6_0_3 nbc6_0_3 0 0.02p
Rbc6_0_4 nbc6_0_3 nbc6_0_4 169000.0
Cbc6_0_4 nbc6_0_4 0 0.02p
Rbc6_0_5 nbc6_0_4 b 169000.0
Rbc6_1_0 bc6in nbc6_1_0 169000.0
Cbc6_1_0 nbc6_1_0 0 0.02p
Rbc6_1_1 nbc6_1_0 nbc6_1_1 169000.0
Cbc6_1_1 nbc6_1_1 0 0.02p
Rbc6_1_2 nbc6_1_1 nbc6_1_2 169000.0
Cbc6_1_2 nbc6_1_2 0 0.02p
Rbc6_1_3 nbc6_1_2 nbc6_1_3 169000.0
Cbc6_1_3 nbc6_1_3 0 0.02p
Rbc6_1_4 nbc6_1_3 nbc6_1_4 169000.0
Cbc6_1_4 nbc6_1_4 0 0.02p
Rbc6_1_5 nbc6_1_4 b 169000.0
Rbc6_2_0 bc6in nbc6_2_0 169000.0
Cbc6_2_0 nbc6_2_0 0 0.02p
Rbc6_2_1 nbc6_2_0 nbc6_2_1 169000.0
Cbc6_2_1 nbc6_2_1 0 0.02p
Rbc6_2_2 nbc6_2_1 nbc6_2_2 169000.0
Cbc6_2_2 nbc6_2_2 0 0.02p
Rbc6_2_3 nbc6_2_2 nbc6_2_3 169000.0
Cbc6_2_3 nbc6_2_3 0 0.02p
Rbc6_2_4 nbc6_2_3 nbc6_2_4 169000.0
Cbc6_2_4 nbc6_2_4 0 0.02p
Rbc6_2_5 nbc6_2_4 b 169000.0
Rbc6_3_0 bc6in nbc6_3_0 169000.0
Cbc6_3_0 nbc6_3_0 0 0.02p
Rbc6_3_1 nbc6_3_0 nbc6_3_1 169000.0
Cbc6_3_1 nbc6_3_1 0 0.02p
Rbc6_3_2 nbc6_3_1 nbc6_3_2 169000.0
Cbc6_3_2 nbc6_3_2 0 0.02p
Rbc6_3_3 nbc6_3_2 nbc6_3_3 169000.0
Cbc6_3_3 nbc6_3_3 0 0.02p
Rbc6_3_4 nbc6_3_3 nbc6_3_4 169000.0
Cbc6_3_4 nbc6_3_4 0 0.02p
Rbc6_3_5 nbc6_3_4 b 169000.0
Rbc6_4_0 bc6in nbc6_4_0 169000.0
Cbc6_4_0 nbc6_4_0 0 0.02p
Rbc6_4_1 nbc6_4_0 nbc6_4_1 169000.0
Cbc6_4_1 nbc6_4_1 0 0.02p
Rbc6_4_2 nbc6_4_1 nbc6_4_2 169000.0
Cbc6_4_2 nbc6_4_2 0 0.02p
Rbc6_4_3 nbc6_4_2 nbc6_4_3 169000.0
Cbc6_4_3 nbc6_4_3 0 0.02p
Rbc6_4_4 nbc6_4_3 nbc6_4_4 169000.0
Cbc6_4_4 nbc6_4_4 0 0.02p
Rbc6_4_5 nbc6_4_4 b 169000.0
Rbc6_5_0 bc6in nbc6_5_0 169000.0
Cbc6_5_0 nbc6_5_0 0 0.02p
Rbc6_5_1 nbc6_5_0 nbc6_5_1 169000.0
Cbc6_5_1 nbc6_5_1 0 0.02p
Rbc6_5_2 nbc6_5_1 nbc6_5_2 169000.0
Cbc6_5_2 nbc6_5_2 0 0.02p
Rbc6_5_3 nbc6_5_2 nbc6_5_3 169000.0
Cbc6_5_3 nbc6_5_3 0 0.02p
Rbc6_5_4 nbc6_5_3 nbc6_5_4 169000.0
Cbc6_5_4 nbc6_5_4 0 0.02p
Rbc6_5_5 nbc6_5_4 b 169000.0
Rbc6_6_0 bc6in nbc6_6_0 169000.0
Cbc6_6_0 nbc6_6_0 0 0.02p
Rbc6_6_1 nbc6_6_0 nbc6_6_1 169000.0
Cbc6_6_1 nbc6_6_1 0 0.02p
Rbc6_6_2 nbc6_6_1 nbc6_6_2 169000.0
Cbc6_6_2 nbc6_6_2 0 0.02p
Rbc6_6_3 nbc6_6_2 nbc6_6_3 169000.0
Cbc6_6_3 nbc6_6_3 0 0.02p
Rbc6_6_4 nbc6_6_3 nbc6_6_4 169000.0
Cbc6_6_4 nbc6_6_4 0 0.02p
Rbc6_6_5 nbc6_6_4 b 169000.0
Rbc6_7_0 bc6in nbc6_7_0 169000.0
Cbc6_7_0 nbc6_7_0 0 0.02p
Rbc6_7_1 nbc6_7_0 nbc6_7_1 169000.0
Cbc6_7_1 nbc6_7_1 0 0.02p
Rbc6_7_2 nbc6_7_1 nbc6_7_2 169000.0
Cbc6_7_2 nbc6_7_2 0 0.02p
Rbc6_7_3 nbc6_7_2 nbc6_7_3 169000.0
Cbc6_7_3 nbc6_7_3 0 0.02p
Rbc6_7_4 nbc6_7_3 nbc6_7_4 169000.0
Cbc6_7_4 nbc6_7_4 0 0.02p
Rbc6_7_5 nbc6_7_4 b 169000.0
Rbc6_8_0 bc6in nbc6_8_0 169000.0
Cbc6_8_0 nbc6_8_0 0 0.02p
Rbc6_8_1 nbc6_8_0 nbc6_8_1 169000.0
Cbc6_8_1 nbc6_8_1 0 0.02p
Rbc6_8_2 nbc6_8_1 nbc6_8_2 169000.0
Cbc6_8_2 nbc6_8_2 0 0.02p
Rbc6_8_3 nbc6_8_2 nbc6_8_3 169000.0
Cbc6_8_3 nbc6_8_3 0 0.02p
Rbc6_8_4 nbc6_8_3 nbc6_8_4 169000.0
Cbc6_8_4 nbc6_8_4 0 0.02p
Rbc6_8_5 nbc6_8_4 b 169000.0
Rbc6_9_0 bc6in nbc6_9_0 169000.0
Cbc6_9_0 nbc6_9_0 0 0.02p
Rbc6_9_1 nbc6_9_0 nbc6_9_1 169000.0
Cbc6_9_1 nbc6_9_1 0 0.02p
Rbc6_9_2 nbc6_9_1 nbc6_9_2 169000.0
Cbc6_9_2 nbc6_9_2 0 0.02p
Rbc6_9_3 nbc6_9_2 nbc6_9_3 169000.0
Cbc6_9_3 nbc6_9_3 0 0.02p
Rbc6_9_4 nbc6_9_3 nbc6_9_4 169000.0
Cbc6_9_4 nbc6_9_4 0 0.02p
Rbc6_9_5 nbc6_9_4 b 169000.0
Rbc6_10_0 bc6in nbc6_10_0 169000.0
Cbc6_10_0 nbc6_10_0 0 0.02p
Rbc6_10_1 nbc6_10_0 nbc6_10_1 169000.0
Cbc6_10_1 nbc6_10_1 0 0.02p
Rbc6_10_2 nbc6_10_1 nbc6_10_2 169000.0
Cbc6_10_2 nbc6_10_2 0 0.02p
Rbc6_10_3 nbc6_10_2 nbc6_10_3 169000.0
Cbc6_10_3 nbc6_10_3 0 0.02p
Rbc6_10_4 nbc6_10_3 nbc6_10_4 169000.0
Cbc6_10_4 nbc6_10_4 0 0.02p
Rbc6_10_5 nbc6_10_4 b 169000.0
Rbc6_11_0 bc6in nbc6_11_0 169000.0
Cbc6_11_0 nbc6_11_0 0 0.02p
Rbc6_11_1 nbc6_11_0 nbc6_11_1 169000.0
Cbc6_11_1 nbc6_11_1 0 0.02p
Rbc6_11_2 nbc6_11_1 nbc6_11_2 169000.0
Cbc6_11_2 nbc6_11_2 0 0.02p
Rbc6_11_3 nbc6_11_2 nbc6_11_3 169000.0
Cbc6_11_3 nbc6_11_3 0 0.02p
Rbc6_11_4 nbc6_11_3 nbc6_11_4 169000.0
Cbc6_11_4 nbc6_11_4 0 0.02p
Rbc6_11_5 nbc6_11_4 b 169000.0
Rbc6_12_0 bc6in nbc6_12_0 169000.0
Cbc6_12_0 nbc6_12_0 0 0.02p
Rbc6_12_1 nbc6_12_0 nbc6_12_1 169000.0
Cbc6_12_1 nbc6_12_1 0 0.02p
Rbc6_12_2 nbc6_12_1 nbc6_12_2 169000.0
Cbc6_12_2 nbc6_12_2 0 0.02p
Rbc6_12_3 nbc6_12_2 nbc6_12_3 169000.0
Cbc6_12_3 nbc6_12_3 0 0.02p
Rbc6_12_4 nbc6_12_3 nbc6_12_4 169000.0
Cbc6_12_4 nbc6_12_4 0 0.02p
Rbc6_12_5 nbc6_12_4 b 169000.0
Rbc6_13_0 bc6in nbc6_13_0 169000.0
Cbc6_13_0 nbc6_13_0 0 0.02p
Rbc6_13_1 nbc6_13_0 nbc6_13_1 169000.0
Cbc6_13_1 nbc6_13_1 0 0.02p
Rbc6_13_2 nbc6_13_1 nbc6_13_2 169000.0
Cbc6_13_2 nbc6_13_2 0 0.02p
Rbc6_13_3 nbc6_13_2 nbc6_13_3 169000.0
Cbc6_13_3 nbc6_13_3 0 0.02p
Rbc6_13_4 nbc6_13_3 nbc6_13_4 169000.0
Cbc6_13_4 nbc6_13_4 0 0.02p
Rbc6_13_5 nbc6_13_4 b 169000.0
Rbc6_14_0 bc6in nbc6_14_0 169000.0
Cbc6_14_0 nbc6_14_0 0 0.02p
Rbc6_14_1 nbc6_14_0 nbc6_14_1 169000.0
Cbc6_14_1 nbc6_14_1 0 0.02p
Rbc6_14_2 nbc6_14_1 nbc6_14_2 169000.0
Cbc6_14_2 nbc6_14_2 0 0.02p
Rbc6_14_3 nbc6_14_2 nbc6_14_3 169000.0
Cbc6_14_3 nbc6_14_3 0 0.02p
Rbc6_14_4 nbc6_14_3 nbc6_14_4 169000.0
Cbc6_14_4 nbc6_14_4 0 0.02p
Rbc6_14_5 nbc6_14_4 b 169000.0
Rbc6_15_0 bc6in nbc6_15_0 169000.0
Cbc6_15_0 nbc6_15_0 0 0.02p
Rbc6_15_1 nbc6_15_0 nbc6_15_1 169000.0
Cbc6_15_1 nbc6_15_1 0 0.02p
Rbc6_15_2 nbc6_15_1 nbc6_15_2 169000.0
Cbc6_15_2 nbc6_15_2 0 0.02p
Rbc6_15_3 nbc6_15_2 nbc6_15_3 169000.0
Cbc6_15_3 nbc6_15_3 0 0.02p
Rbc6_15_4 nbc6_15_3 nbc6_15_4 169000.0
Cbc6_15_4 nbc6_15_4 0 0.02p
Rbc6_15_5 nbc6_15_4 b 169000.0
Rbc6_16_0 bc6in nbc6_16_0 169000.0
Cbc6_16_0 nbc6_16_0 0 0.02p
Rbc6_16_1 nbc6_16_0 nbc6_16_1 169000.0
Cbc6_16_1 nbc6_16_1 0 0.02p
Rbc6_16_2 nbc6_16_1 nbc6_16_2 169000.0
Cbc6_16_2 nbc6_16_2 0 0.02p
Rbc6_16_3 nbc6_16_2 nbc6_16_3 169000.0
Cbc6_16_3 nbc6_16_3 0 0.02p
Rbc6_16_4 nbc6_16_3 nbc6_16_4 169000.0
Cbc6_16_4 nbc6_16_4 0 0.02p
Rbc6_16_5 nbc6_16_4 b 169000.0
Rbc6_17_0 bc6in nbc6_17_0 169000.0
Cbc6_17_0 nbc6_17_0 0 0.02p
Rbc6_17_1 nbc6_17_0 nbc6_17_1 169000.0
Cbc6_17_1 nbc6_17_1 0 0.02p
Rbc6_17_2 nbc6_17_1 nbc6_17_2 169000.0
Cbc6_17_2 nbc6_17_2 0 0.02p
Rbc6_17_3 nbc6_17_2 nbc6_17_3 169000.0
Cbc6_17_3 nbc6_17_3 0 0.02p
Rbc6_17_4 nbc6_17_3 nbc6_17_4 169000.0
Cbc6_17_4 nbc6_17_4 0 0.02p
Rbc6_17_5 nbc6_17_4 b 169000.0
Rbc6_18_0 bc6in nbc6_18_0 169000.0
Cbc6_18_0 nbc6_18_0 0 0.02p
Rbc6_18_1 nbc6_18_0 nbc6_18_1 169000.0
Cbc6_18_1 nbc6_18_1 0 0.02p
Rbc6_18_2 nbc6_18_1 nbc6_18_2 169000.0
Cbc6_18_2 nbc6_18_2 0 0.02p
Rbc6_18_3 nbc6_18_2 nbc6_18_3 169000.0
Cbc6_18_3 nbc6_18_3 0 0.02p
Rbc6_18_4 nbc6_18_3 nbc6_18_4 169000.0
Cbc6_18_4 nbc6_18_4 0 0.02p
Rbc6_18_5 nbc6_18_4 b 169000.0
Rbc6_19_0 bc6in nbc6_19_0 169000.0
Cbc6_19_0 nbc6_19_0 0 0.02p
Rbc6_19_1 nbc6_19_0 nbc6_19_1 169000.0
Cbc6_19_1 nbc6_19_1 0 0.02p
Rbc6_19_2 nbc6_19_1 nbc6_19_2 169000.0
Cbc6_19_2 nbc6_19_2 0 0.02p
Rbc6_19_3 nbc6_19_2 nbc6_19_3 169000.0
Cbc6_19_3 nbc6_19_3 0 0.02p
Rbc6_19_4 nbc6_19_3 nbc6_19_4 169000.0
Cbc6_19_4 nbc6_19_4 0 0.02p
Rbc6_19_5 nbc6_19_4 b 169000.0
Rbc6_20_0 bc6in nbc6_20_0 169000.0
Cbc6_20_0 nbc6_20_0 0 0.02p
Rbc6_20_1 nbc6_20_0 nbc6_20_1 169000.0
Cbc6_20_1 nbc6_20_1 0 0.02p
Rbc6_20_2 nbc6_20_1 nbc6_20_2 169000.0
Cbc6_20_2 nbc6_20_2 0 0.02p
Rbc6_20_3 nbc6_20_2 nbc6_20_3 169000.0
Cbc6_20_3 nbc6_20_3 0 0.02p
Rbc6_20_4 nbc6_20_3 nbc6_20_4 169000.0
Cbc6_20_4 nbc6_20_4 0 0.02p
Rbc6_20_5 nbc6_20_4 b 169000.0
Rbc6_21_0 bc6in nbc6_21_0 169000.0
Cbc6_21_0 nbc6_21_0 0 0.02p
Rbc6_21_1 nbc6_21_0 nbc6_21_1 169000.0
Cbc6_21_1 nbc6_21_1 0 0.02p
Rbc6_21_2 nbc6_21_1 nbc6_21_2 169000.0
Cbc6_21_2 nbc6_21_2 0 0.02p
Rbc6_21_3 nbc6_21_2 nbc6_21_3 169000.0
Cbc6_21_3 nbc6_21_3 0 0.02p
Rbc6_21_4 nbc6_21_3 nbc6_21_4 169000.0
Cbc6_21_4 nbc6_21_4 0 0.02p
Rbc6_21_5 nbc6_21_4 b 169000.0
Rbc6_22_0 bc6in nbc6_22_0 169000.0
Cbc6_22_0 nbc6_22_0 0 0.02p
Rbc6_22_1 nbc6_22_0 nbc6_22_1 169000.0
Cbc6_22_1 nbc6_22_1 0 0.02p
Rbc6_22_2 nbc6_22_1 nbc6_22_2 169000.0
Cbc6_22_2 nbc6_22_2 0 0.02p
Rbc6_22_3 nbc6_22_2 nbc6_22_3 169000.0
Cbc6_22_3 nbc6_22_3 0 0.02p
Rbc6_22_4 nbc6_22_3 nbc6_22_4 169000.0
Cbc6_22_4 nbc6_22_4 0 0.02p
Rbc6_22_5 nbc6_22_4 b 169000.0
Rbc6_23_0 bc6in nbc6_23_0 169000.0
Cbc6_23_0 nbc6_23_0 0 0.02p
Rbc6_23_1 nbc6_23_0 nbc6_23_1 169000.0
Cbc6_23_1 nbc6_23_1 0 0.02p
Rbc6_23_2 nbc6_23_1 nbc6_23_2 169000.0
Cbc6_23_2 nbc6_23_2 0 0.02p
Rbc6_23_3 nbc6_23_2 nbc6_23_3 169000.0
Cbc6_23_3 nbc6_23_3 0 0.02p
Rbc6_23_4 nbc6_23_3 nbc6_23_4 169000.0
Cbc6_23_4 nbc6_23_4 0 0.02p
Rbc6_23_5 nbc6_23_4 b 169000.0
Vbf0 bf0in 0 DC 0 AC -0.5
Rbf0_0_0 bf0in nbf0_0_0 169000.0
Cbf0_0_0 nbf0_0_0 0 0.02p
Rbf0_0_1 nbf0_0_0 nbf0_0_1 169000.0
Cbf0_0_1 nbf0_0_1 0 0.02p
Rbf0_0_2 nbf0_0_1 nbf0_0_2 169000.0
Cbf0_0_2 nbf0_0_2 0 0.02p
Rbf0_0_3 nbf0_0_2 nbf0_0_3 169000.0
Cbf0_0_3 nbf0_0_3 0 0.02p
Rbf0_0_4 nbf0_0_3 nbf0_0_4 169000.0
Cbf0_0_4 nbf0_0_4 0 0.02p
Rbf0_0_5 nbf0_0_4 nbf0_0_5 169000.0
Cbf0_0_5 nbf0_0_5 0 0.02p
Rbf0_0_6 nbf0_0_5 nbf0_0_6 169000.0
Cbf0_0_6 nbf0_0_6 0 0.02p
Rbf0_0_7 nbf0_0_6 nbf0_0_7 169000.0
Cbf0_0_7 nbf0_0_7 0 0.02p
Rbf0_0_8 nbf0_0_7 nbf0_0_8 169000.0
Cbf0_0_8 nbf0_0_8 0 0.02p
Rbf0_0_9 nbf0_0_8 nbf0_0_9 169000.0
Cbf0_0_9 nbf0_0_9 0 0.02p
Rbf0_0_10 nbf0_0_9 nbf0_0_10 169000.0
Cbf0_0_10 nbf0_0_10 0 0.02p
Rbf0_0_11 nbf0_0_10 nbf0_0_11 169000.0
Cbf0_0_11 nbf0_0_11 0 0.02p
Rbf0_0_12 nbf0_0_11 nbf0_0_12 169000.0
Cbf0_0_12 nbf0_0_12 0 0.02p
Rbf0_0_13 nbf0_0_12 nbf0_0_13 169000.0
Cbf0_0_13 nbf0_0_13 0 0.02p
Rbf0_0_14 nbf0_0_13 nbf0_0_14 169000.0
Cbf0_0_14 nbf0_0_14 0 0.02p
Rbf0_0_15 nbf0_0_14 nbf0_0_15 169000.0
Cbf0_0_15 nbf0_0_15 0 0.02p
Rbf0_0_16 nbf0_0_15 nbf0_0_16 169000.0
Cbf0_0_16 nbf0_0_16 0 0.02p
Rbf0_0_17 nbf0_0_16 nbf0_0_17 169000.0
Cbf0_0_17 nbf0_0_17 0 0.02p
Rbf0_0_18 nbf0_0_17 nbf0_0_18 169000.0
Cbf0_0_18 nbf0_0_18 0 0.02p
Rbf0_0_19 nbf0_0_18 nbf0_0_19 169000.0
Cbf0_0_19 nbf0_0_19 0 0.02p
Rbf0_0_20 nbf0_0_19 nbf0_0_20 169000.0
Cbf0_0_20 nbf0_0_20 0 0.02p
Rbf0_0_21 nbf0_0_20 nbf0_0_21 169000.0
Cbf0_0_21 nbf0_0_21 0 0.02p
Rbf0_0_22 nbf0_0_21 nbf0_0_22 169000.0
Cbf0_0_22 nbf0_0_22 0 0.02p
Rbf0_0_23 nbf0_0_22 nbf0_0_23 169000.0
Cbf0_0_23 nbf0_0_23 0 0.02p
Rbf0_0_24 nbf0_0_23 nbf0_0_24 169000.0
Cbf0_0_24 nbf0_0_24 0 0.02p
Rbf0_0_25 nbf0_0_24 nbf0_0_25 169000.0
Cbf0_0_25 nbf0_0_25 0 0.02p
Rbf0_0_26 nbf0_0_25 nbf0_0_26 169000.0
Cbf0_0_26 nbf0_0_26 0 0.02p
Rbf0_0_27 nbf0_0_26 nbf0_0_27 169000.0
Cbf0_0_27 nbf0_0_27 0 0.02p
Rbf0_0_28 nbf0_0_27 nbf0_0_28 169000.0
Cbf0_0_28 nbf0_0_28 0 0.02p
Rbf0_0_29 nbf0_0_28 nbf0_0_29 169000.0
Cbf0_0_29 nbf0_0_29 0 0.02p
Rbf0_0_30 nbf0_0_29 nbf0_0_30 169000.0
Cbf0_0_30 nbf0_0_30 0 0.02p
Rbf0_0_31 nbf0_0_30 nbf0_0_31 169000.0
Cbf0_0_31 nbf0_0_31 0 0.02p
Rbf0_0_32 nbf0_0_31 nbf0_0_32 169000.0
Cbf0_0_32 nbf0_0_32 0 0.02p
Rbf0_0_33 nbf0_0_32 nbf0_0_33 169000.0
Cbf0_0_33 nbf0_0_33 0 0.02p
Rbf0_0_34 nbf0_0_33 nbf0_0_34 169000.0
Cbf0_0_34 nbf0_0_34 0 0.02p
Rbf0_0_35 nbf0_0_34 nbf0_0_35 169000.0
Cbf0_0_35 nbf0_0_35 0 0.02p
Rbf0_0_36 nbf0_0_35 nbf0_0_36 169000.0
Cbf0_0_36 nbf0_0_36 0 0.02p
Rbf0_0_37 nbf0_0_36 nbf0_0_37 169000.0
Cbf0_0_37 nbf0_0_37 0 0.02p
Rbf0_0_38 nbf0_0_37 nbf0_0_38 169000.0
Cbf0_0_38 nbf0_0_38 0 0.02p
Rbf0_0_39 nbf0_0_38 nbf0_0_39 169000.0
Cbf0_0_39 nbf0_0_39 0 0.02p
Rbf0_0_40 nbf0_0_39 nbf0_0_40 169000.0
Cbf0_0_40 nbf0_0_40 0 0.02p
Rbf0_0_41 nbf0_0_40 nbf0_0_41 169000.0
Cbf0_0_41 nbf0_0_41 0 0.02p
Rbf0_0_42 nbf0_0_41 nbf0_0_42 169000.0
Cbf0_0_42 nbf0_0_42 0 0.02p
Rbf0_0_43 nbf0_0_42 nbf0_0_43 169000.0
Cbf0_0_43 nbf0_0_43 0 0.02p
Rbf0_0_44 nbf0_0_43 nbf0_0_44 169000.0
Cbf0_0_44 nbf0_0_44 0 0.02p
Rbf0_0_45 nbf0_0_44 nbf0_0_45 169000.0
Cbf0_0_45 nbf0_0_45 0 0.02p
Rbf0_0_46 nbf0_0_45 nbf0_0_46 169000.0
Cbf0_0_46 nbf0_0_46 0 0.02p
Rbf0_0_47 nbf0_0_46 nbf0_0_47 169000.0
Cbf0_0_47 nbf0_0_47 0 0.02p
Rbf0_0_48 nbf0_0_47 nbf0_0_48 169000.0
Cbf0_0_48 nbf0_0_48 0 0.02p
Rbf0_0_49 nbf0_0_48 nbf0_0_49 169000.0
Cbf0_0_49 nbf0_0_49 0 0.02p
Rbf0_0_50 nbf0_0_49 nbf0_0_50 169000.0
Cbf0_0_50 nbf0_0_50 0 0.02p
Rbf0_0_51 nbf0_0_50 nbf0_0_51 169000.0
Cbf0_0_51 nbf0_0_51 0 0.02p
Rbf0_0_52 nbf0_0_51 nbf0_0_52 169000.0
Cbf0_0_52 nbf0_0_52 0 0.02p
Rbf0_0_53 nbf0_0_52 nbf0_0_53 169000.0
Cbf0_0_53 nbf0_0_53 0 0.02p
Rbf0_0_54 nbf0_0_53 nbf0_0_54 169000.0
Cbf0_0_54 nbf0_0_54 0 0.02p
Rbf0_0_55 nbf0_0_54 nbf0_0_55 169000.0
Cbf0_0_55 nbf0_0_55 0 0.02p
Rbf0_0_56 nbf0_0_55 nbf0_0_56 169000.0
Cbf0_0_56 nbf0_0_56 0 0.02p
Rbf0_0_57 nbf0_0_56 nbf0_0_57 169000.0
Cbf0_0_57 nbf0_0_57 0 0.02p
Rbf0_0_58 nbf0_0_57 nbf0_0_58 169000.0
Cbf0_0_58 nbf0_0_58 0 0.02p
Rbf0_0_59 nbf0_0_58 nbf0_0_59 169000.0
Cbf0_0_59 nbf0_0_59 0 0.02p
Rbf0_0_60 nbf0_0_59 nbf0_0_60 169000.0
Cbf0_0_60 nbf0_0_60 0 0.02p
Rbf0_0_61 nbf0_0_60 nbf0_0_61 169000.0
Cbf0_0_61 nbf0_0_61 0 0.02p
Rbf0_0_62 nbf0_0_61 nbf0_0_62 169000.0
Cbf0_0_62 nbf0_0_62 0 0.02p
Rbf0_0_63 nbf0_0_62 nbf0_0_63 169000.0
Cbf0_0_63 nbf0_0_63 0 0.02p
Rbf0_0_64 nbf0_0_63 nbf0_0_64 169000.0
Cbf0_0_64 nbf0_0_64 0 0.02p
Rbf0_0_65 nbf0_0_64 nbf0_0_65 169000.0
Cbf0_0_65 nbf0_0_65 0 0.02p
Rbf0_0_66 nbf0_0_65 nbf0_0_66 169000.0
Cbf0_0_66 nbf0_0_66 0 0.02p
Rbf0_0_67 nbf0_0_66 nbf0_0_67 169000.0
Cbf0_0_67 nbf0_0_67 0 0.02p
Rbf0_0_68 nbf0_0_67 nbf0_0_68 169000.0
Cbf0_0_68 nbf0_0_68 0 0.02p
Rbf0_0_69 nbf0_0_68 nbf0_0_69 169000.0
Cbf0_0_69 nbf0_0_69 0 0.02p
Rbf0_0_70 nbf0_0_69 nbf0_0_70 169000.0
Cbf0_0_70 nbf0_0_70 0 0.02p
Rbf0_0_71 nbf0_0_70 nbf0_0_71 169000.0
Cbf0_0_71 nbf0_0_71 0 0.02p
Rbf0_0_72 nbf0_0_71 nbf0_0_72 169000.0
Cbf0_0_72 nbf0_0_72 0 0.02p
Rbf0_0_73 nbf0_0_72 nbf0_0_73 169000.0
Cbf0_0_73 nbf0_0_73 0 0.02p
Rbf0_0_74 nbf0_0_73 nbf0_0_74 169000.0
Cbf0_0_74 nbf0_0_74 0 0.02p
Rbf0_0_75 nbf0_0_74 nbf0_0_75 169000.0
Cbf0_0_75 nbf0_0_75 0 0.02p
Rbf0_0_76 nbf0_0_75 nbf0_0_76 169000.0
Cbf0_0_76 nbf0_0_76 0 0.02p
Rbf0_0_77 nbf0_0_76 nbf0_0_77 169000.0
Cbf0_0_77 nbf0_0_77 0 0.02p
Rbf0_0_78 nbf0_0_77 nbf0_0_78 169000.0
Cbf0_0_78 nbf0_0_78 0 0.02p
Rbf0_0_79 nbf0_0_78 nbf0_0_79 169000.0
Cbf0_0_79 nbf0_0_79 0 0.02p
Rbf0_0_80 nbf0_0_79 nbf0_0_80 169000.0
Cbf0_0_80 nbf0_0_80 0 0.02p
Rbf0_0_81 nbf0_0_80 nbf0_0_81 169000.0
Cbf0_0_81 nbf0_0_81 0 0.02p
Rbf0_0_82 nbf0_0_81 nbf0_0_82 169000.0
Cbf0_0_82 nbf0_0_82 0 0.02p
Rbf0_0_83 nbf0_0_82 nbf0_0_83 169000.0
Cbf0_0_83 nbf0_0_83 0 0.02p
Rbf0_0_84 nbf0_0_83 nbf0_0_84 169000.0
Cbf0_0_84 nbf0_0_84 0 0.02p
Rbf0_0_85 nbf0_0_84 nbf0_0_85 169000.0
Cbf0_0_85 nbf0_0_85 0 0.02p
Rbf0_0_86 nbf0_0_85 nbf0_0_86 169000.0
Cbf0_0_86 nbf0_0_86 0 0.02p
Rbf0_0_87 nbf0_0_86 nbf0_0_87 169000.0
Cbf0_0_87 nbf0_0_87 0 0.02p
Rbf0_0_88 nbf0_0_87 nbf0_0_88 169000.0
Cbf0_0_88 nbf0_0_88 0 0.02p
Rbf0_0_89 nbf0_0_88 nbf0_0_89 169000.0
Cbf0_0_89 nbf0_0_89 0 0.02p
Rbf0_0_90 nbf0_0_89 nbf0_0_90 169000.0
Cbf0_0_90 nbf0_0_90 0 0.02p
Rbf0_0_91 nbf0_0_90 nbf0_0_91 169000.0
Cbf0_0_91 nbf0_0_91 0 0.02p
Rbf0_0_92 nbf0_0_91 nbf0_0_92 169000.0
Cbf0_0_92 nbf0_0_92 0 0.02p
Rbf0_0_93 nbf0_0_92 nbf0_0_93 169000.0
Cbf0_0_93 nbf0_0_93 0 0.02p
Rbf0_0_94 nbf0_0_93 nbf0_0_94 169000.0
Cbf0_0_94 nbf0_0_94 0 0.02p
Rbf0_0_95 nbf0_0_94 nbf0_0_95 169000.0
Cbf0_0_95 nbf0_0_95 0 0.02p
Rbf0_0_96 nbf0_0_95 nbf0_0_96 169000.0
Cbf0_0_96 nbf0_0_96 0 0.02p
Rbf0_0_97 nbf0_0_96 nbf0_0_97 169000.0
Cbf0_0_97 nbf0_0_97 0 0.02p
Rbf0_0_98 nbf0_0_97 nbf0_0_98 169000.0
Cbf0_0_98 nbf0_0_98 0 0.02p
Rbf0_0_99 nbf0_0_98 nbf0_0_99 169000.0
Cbf0_0_99 nbf0_0_99 0 0.02p
Rbf0_0_100 nbf0_0_99 nbf0_0_100 169000.0
Cbf0_0_100 nbf0_0_100 0 0.02p
Rbf0_0_101 nbf0_0_100 nbf0_0_101 169000.0
Cbf0_0_101 nbf0_0_101 0 0.02p
Rbf0_0_102 nbf0_0_101 nbf0_0_102 169000.0
Cbf0_0_102 nbf0_0_102 0 0.02p
Rbf0_0_103 nbf0_0_102 nbf0_0_103 169000.0
Cbf0_0_103 nbf0_0_103 0 0.02p
Rbf0_0_104 nbf0_0_103 nbf0_0_104 169000.0
Cbf0_0_104 nbf0_0_104 0 0.02p
Rbf0_0_105 nbf0_0_104 nbf0_0_105 169000.0
Cbf0_0_105 nbf0_0_105 0 0.02p
Rbf0_0_106 nbf0_0_105 nbf0_0_106 169000.0
Cbf0_0_106 nbf0_0_106 0 0.02p
Rbf0_0_107 nbf0_0_106 nbf0_0_107 169000.0
Cbf0_0_107 nbf0_0_107 0 0.02p
Rbf0_0_108 nbf0_0_107 nbf0_0_108 169000.0
Cbf0_0_108 nbf0_0_108 0 0.02p
Rbf0_0_109 nbf0_0_108 nbf0_0_109 169000.0
Cbf0_0_109 nbf0_0_109 0 0.02p
Rbf0_0_110 nbf0_0_109 nbf0_0_110 169000.0
Cbf0_0_110 nbf0_0_110 0 0.02p
Rbf0_0_111 nbf0_0_110 nbf0_0_111 169000.0
Cbf0_0_111 nbf0_0_111 0 0.02p
Rbf0_0_112 nbf0_0_111 nbf0_0_112 169000.0
Cbf0_0_112 nbf0_0_112 0 0.02p
Rbf0_0_113 nbf0_0_112 nbf0_0_113 169000.0
Cbf0_0_113 nbf0_0_113 0 0.02p
Rbf0_0_114 nbf0_0_113 nbf0_0_114 169000.0
Cbf0_0_114 nbf0_0_114 0 0.02p
Rbf0_0_115 nbf0_0_114 nbf0_0_115 169000.0
Cbf0_0_115 nbf0_0_115 0 0.02p
Rbf0_0_116 nbf0_0_115 nbf0_0_116 169000.0
Cbf0_0_116 nbf0_0_116 0 0.02p
Rbf0_0_117 nbf0_0_116 nbf0_0_117 169000.0
Cbf0_0_117 nbf0_0_117 0 0.02p
Rbf0_0_118 nbf0_0_117 nbf0_0_118 169000.0
Cbf0_0_118 nbf0_0_118 0 0.02p
Rbf0_0_119 nbf0_0_118 nbf0_0_119 169000.0
Cbf0_0_119 nbf0_0_119 0 0.02p
Rbf0_0_120 nbf0_0_119 nbf0_0_120 169000.0
Cbf0_0_120 nbf0_0_120 0 0.02p
Rbf0_0_121 nbf0_0_120 nbf0_0_121 169000.0
Cbf0_0_121 nbf0_0_121 0 0.02p
Rbf0_0_122 nbf0_0_121 nbf0_0_122 169000.0
Cbf0_0_122 nbf0_0_122 0 0.02p
Rbf0_0_123 nbf0_0_122 nbf0_0_123 169000.0
Cbf0_0_123 nbf0_0_123 0 0.02p
Rbf0_0_124 nbf0_0_123 nbf0_0_124 169000.0
Cbf0_0_124 nbf0_0_124 0 0.02p
Rbf0_0_125 nbf0_0_124 nbf0_0_125 169000.0
Cbf0_0_125 nbf0_0_125 0 0.02p
Rbf0_0_126 nbf0_0_125 nbf0_0_126 169000.0
Cbf0_0_126 nbf0_0_126 0 0.02p
Rbf0_0_127 nbf0_0_126 b 169000.0
Vbf1 bf1in 0 DC 0 AC -0.5
Rbf1_0_0 bf1in nbf1_0_0 169000.0
Cbf1_0_0 nbf1_0_0 0 0.02p
Rbf1_0_1 nbf1_0_0 nbf1_0_1 169000.0
Cbf1_0_1 nbf1_0_1 0 0.02p
Rbf1_0_2 nbf1_0_1 nbf1_0_2 169000.0
Cbf1_0_2 nbf1_0_2 0 0.02p
Rbf1_0_3 nbf1_0_2 nbf1_0_3 169000.0
Cbf1_0_3 nbf1_0_3 0 0.02p
Rbf1_0_4 nbf1_0_3 nbf1_0_4 169000.0
Cbf1_0_4 nbf1_0_4 0 0.02p
Rbf1_0_5 nbf1_0_4 nbf1_0_5 169000.0
Cbf1_0_5 nbf1_0_5 0 0.02p
Rbf1_0_6 nbf1_0_5 nbf1_0_6 169000.0
Cbf1_0_6 nbf1_0_6 0 0.02p
Rbf1_0_7 nbf1_0_6 nbf1_0_7 169000.0
Cbf1_0_7 nbf1_0_7 0 0.02p
Rbf1_0_8 nbf1_0_7 nbf1_0_8 169000.0
Cbf1_0_8 nbf1_0_8 0 0.02p
Rbf1_0_9 nbf1_0_8 nbf1_0_9 169000.0
Cbf1_0_9 nbf1_0_9 0 0.02p
Rbf1_0_10 nbf1_0_9 nbf1_0_10 169000.0
Cbf1_0_10 nbf1_0_10 0 0.02p
Rbf1_0_11 nbf1_0_10 nbf1_0_11 169000.0
Cbf1_0_11 nbf1_0_11 0 0.02p
Rbf1_0_12 nbf1_0_11 nbf1_0_12 169000.0
Cbf1_0_12 nbf1_0_12 0 0.02p
Rbf1_0_13 nbf1_0_12 nbf1_0_13 169000.0
Cbf1_0_13 nbf1_0_13 0 0.02p
Rbf1_0_14 nbf1_0_13 nbf1_0_14 169000.0
Cbf1_0_14 nbf1_0_14 0 0.02p
Rbf1_0_15 nbf1_0_14 nbf1_0_15 169000.0
Cbf1_0_15 nbf1_0_15 0 0.02p
Rbf1_0_16 nbf1_0_15 nbf1_0_16 169000.0
Cbf1_0_16 nbf1_0_16 0 0.02p
Rbf1_0_17 nbf1_0_16 nbf1_0_17 169000.0
Cbf1_0_17 nbf1_0_17 0 0.02p
Rbf1_0_18 nbf1_0_17 nbf1_0_18 169000.0
Cbf1_0_18 nbf1_0_18 0 0.02p
Rbf1_0_19 nbf1_0_18 nbf1_0_19 169000.0
Cbf1_0_19 nbf1_0_19 0 0.02p
Rbf1_0_20 nbf1_0_19 nbf1_0_20 169000.0
Cbf1_0_20 nbf1_0_20 0 0.02p
Rbf1_0_21 nbf1_0_20 nbf1_0_21 169000.0
Cbf1_0_21 nbf1_0_21 0 0.02p
Rbf1_0_22 nbf1_0_21 nbf1_0_22 169000.0
Cbf1_0_22 nbf1_0_22 0 0.02p
Rbf1_0_23 nbf1_0_22 nbf1_0_23 169000.0
Cbf1_0_23 nbf1_0_23 0 0.02p
Rbf1_0_24 nbf1_0_23 nbf1_0_24 169000.0
Cbf1_0_24 nbf1_0_24 0 0.02p
Rbf1_0_25 nbf1_0_24 nbf1_0_25 169000.0
Cbf1_0_25 nbf1_0_25 0 0.02p
Rbf1_0_26 nbf1_0_25 nbf1_0_26 169000.0
Cbf1_0_26 nbf1_0_26 0 0.02p
Rbf1_0_27 nbf1_0_26 nbf1_0_27 169000.0
Cbf1_0_27 nbf1_0_27 0 0.02p
Rbf1_0_28 nbf1_0_27 nbf1_0_28 169000.0
Cbf1_0_28 nbf1_0_28 0 0.02p
Rbf1_0_29 nbf1_0_28 nbf1_0_29 169000.0
Cbf1_0_29 nbf1_0_29 0 0.02p
Rbf1_0_30 nbf1_0_29 nbf1_0_30 169000.0
Cbf1_0_30 nbf1_0_30 0 0.02p
Rbf1_0_31 nbf1_0_30 nbf1_0_31 169000.0
Cbf1_0_31 nbf1_0_31 0 0.02p
Rbf1_0_32 nbf1_0_31 nbf1_0_32 169000.0
Cbf1_0_32 nbf1_0_32 0 0.02p
Rbf1_0_33 nbf1_0_32 nbf1_0_33 169000.0
Cbf1_0_33 nbf1_0_33 0 0.02p
Rbf1_0_34 nbf1_0_33 nbf1_0_34 169000.0
Cbf1_0_34 nbf1_0_34 0 0.02p
Rbf1_0_35 nbf1_0_34 nbf1_0_35 169000.0
Cbf1_0_35 nbf1_0_35 0 0.02p
Rbf1_0_36 nbf1_0_35 nbf1_0_36 169000.0
Cbf1_0_36 nbf1_0_36 0 0.02p
Rbf1_0_37 nbf1_0_36 nbf1_0_37 169000.0
Cbf1_0_37 nbf1_0_37 0 0.02p
Rbf1_0_38 nbf1_0_37 nbf1_0_38 169000.0
Cbf1_0_38 nbf1_0_38 0 0.02p
Rbf1_0_39 nbf1_0_38 nbf1_0_39 169000.0
Cbf1_0_39 nbf1_0_39 0 0.02p
Rbf1_0_40 nbf1_0_39 nbf1_0_40 169000.0
Cbf1_0_40 nbf1_0_40 0 0.02p
Rbf1_0_41 nbf1_0_40 nbf1_0_41 169000.0
Cbf1_0_41 nbf1_0_41 0 0.02p
Rbf1_0_42 nbf1_0_41 nbf1_0_42 169000.0
Cbf1_0_42 nbf1_0_42 0 0.02p
Rbf1_0_43 nbf1_0_42 nbf1_0_43 169000.0
Cbf1_0_43 nbf1_0_43 0 0.02p
Rbf1_0_44 nbf1_0_43 nbf1_0_44 169000.0
Cbf1_0_44 nbf1_0_44 0 0.02p
Rbf1_0_45 nbf1_0_44 nbf1_0_45 169000.0
Cbf1_0_45 nbf1_0_45 0 0.02p
Rbf1_0_46 nbf1_0_45 nbf1_0_46 169000.0
Cbf1_0_46 nbf1_0_46 0 0.02p
Rbf1_0_47 nbf1_0_46 nbf1_0_47 169000.0
Cbf1_0_47 nbf1_0_47 0 0.02p
Rbf1_0_48 nbf1_0_47 nbf1_0_48 169000.0
Cbf1_0_48 nbf1_0_48 0 0.02p
Rbf1_0_49 nbf1_0_48 nbf1_0_49 169000.0
Cbf1_0_49 nbf1_0_49 0 0.02p
Rbf1_0_50 nbf1_0_49 nbf1_0_50 169000.0
Cbf1_0_50 nbf1_0_50 0 0.02p
Rbf1_0_51 nbf1_0_50 nbf1_0_51 169000.0
Cbf1_0_51 nbf1_0_51 0 0.02p
Rbf1_0_52 nbf1_0_51 nbf1_0_52 169000.0
Cbf1_0_52 nbf1_0_52 0 0.02p
Rbf1_0_53 nbf1_0_52 nbf1_0_53 169000.0
Cbf1_0_53 nbf1_0_53 0 0.02p
Rbf1_0_54 nbf1_0_53 nbf1_0_54 169000.0
Cbf1_0_54 nbf1_0_54 0 0.02p
Rbf1_0_55 nbf1_0_54 nbf1_0_55 169000.0
Cbf1_0_55 nbf1_0_55 0 0.02p
Rbf1_0_56 nbf1_0_55 nbf1_0_56 169000.0
Cbf1_0_56 nbf1_0_56 0 0.02p
Rbf1_0_57 nbf1_0_56 nbf1_0_57 169000.0
Cbf1_0_57 nbf1_0_57 0 0.02p
Rbf1_0_58 nbf1_0_57 nbf1_0_58 169000.0
Cbf1_0_58 nbf1_0_58 0 0.02p
Rbf1_0_59 nbf1_0_58 nbf1_0_59 169000.0
Cbf1_0_59 nbf1_0_59 0 0.02p
Rbf1_0_60 nbf1_0_59 nbf1_0_60 169000.0
Cbf1_0_60 nbf1_0_60 0 0.02p
Rbf1_0_61 nbf1_0_60 nbf1_0_61 169000.0
Cbf1_0_61 nbf1_0_61 0 0.02p
Rbf1_0_62 nbf1_0_61 nbf1_0_62 169000.0
Cbf1_0_62 nbf1_0_62 0 0.02p
Rbf1_0_63 nbf1_0_62 b 169000.0
Vbf2 bf2in 0 DC 0 AC -0.5
Rbf2_0_0 bf2in nbf2_0_0 169000.0
Cbf2_0_0 nbf2_0_0 0 0.02p
Rbf2_0_1 nbf2_0_0 nbf2_0_1 169000.0
Cbf2_0_1 nbf2_0_1 0 0.02p
Rbf2_0_2 nbf2_0_1 nbf2_0_2 169000.0
Cbf2_0_2 nbf2_0_2 0 0.02p
Rbf2_0_3 nbf2_0_2 nbf2_0_3 169000.0
Cbf2_0_3 nbf2_0_3 0 0.02p
Rbf2_0_4 nbf2_0_3 nbf2_0_4 169000.0
Cbf2_0_4 nbf2_0_4 0 0.02p
Rbf2_0_5 nbf2_0_4 nbf2_0_5 169000.0
Cbf2_0_5 nbf2_0_5 0 0.02p
Rbf2_0_6 nbf2_0_5 nbf2_0_6 169000.0
Cbf2_0_6 nbf2_0_6 0 0.02p
Rbf2_0_7 nbf2_0_6 nbf2_0_7 169000.0
Cbf2_0_7 nbf2_0_7 0 0.02p
Rbf2_0_8 nbf2_0_7 nbf2_0_8 169000.0
Cbf2_0_8 nbf2_0_8 0 0.02p
Rbf2_0_9 nbf2_0_8 nbf2_0_9 169000.0
Cbf2_0_9 nbf2_0_9 0 0.02p
Rbf2_0_10 nbf2_0_9 nbf2_0_10 169000.0
Cbf2_0_10 nbf2_0_10 0 0.02p
Rbf2_0_11 nbf2_0_10 nbf2_0_11 169000.0
Cbf2_0_11 nbf2_0_11 0 0.02p
Rbf2_0_12 nbf2_0_11 nbf2_0_12 169000.0
Cbf2_0_12 nbf2_0_12 0 0.02p
Rbf2_0_13 nbf2_0_12 nbf2_0_13 169000.0
Cbf2_0_13 nbf2_0_13 0 0.02p
Rbf2_0_14 nbf2_0_13 nbf2_0_14 169000.0
Cbf2_0_14 nbf2_0_14 0 0.02p
Rbf2_0_15 nbf2_0_14 nbf2_0_15 169000.0
Cbf2_0_15 nbf2_0_15 0 0.02p
Rbf2_0_16 nbf2_0_15 nbf2_0_16 169000.0
Cbf2_0_16 nbf2_0_16 0 0.02p
Rbf2_0_17 nbf2_0_16 nbf2_0_17 169000.0
Cbf2_0_17 nbf2_0_17 0 0.02p
Rbf2_0_18 nbf2_0_17 nbf2_0_18 169000.0
Cbf2_0_18 nbf2_0_18 0 0.02p
Rbf2_0_19 nbf2_0_18 nbf2_0_19 169000.0
Cbf2_0_19 nbf2_0_19 0 0.02p
Rbf2_0_20 nbf2_0_19 nbf2_0_20 169000.0
Cbf2_0_20 nbf2_0_20 0 0.02p
Rbf2_0_21 nbf2_0_20 nbf2_0_21 169000.0
Cbf2_0_21 nbf2_0_21 0 0.02p
Rbf2_0_22 nbf2_0_21 nbf2_0_22 169000.0
Cbf2_0_22 nbf2_0_22 0 0.02p
Rbf2_0_23 nbf2_0_22 nbf2_0_23 169000.0
Cbf2_0_23 nbf2_0_23 0 0.02p
Rbf2_0_24 nbf2_0_23 nbf2_0_24 169000.0
Cbf2_0_24 nbf2_0_24 0 0.02p
Rbf2_0_25 nbf2_0_24 nbf2_0_25 169000.0
Cbf2_0_25 nbf2_0_25 0 0.02p
Rbf2_0_26 nbf2_0_25 nbf2_0_26 169000.0
Cbf2_0_26 nbf2_0_26 0 0.02p
Rbf2_0_27 nbf2_0_26 nbf2_0_27 169000.0
Cbf2_0_27 nbf2_0_27 0 0.02p
Rbf2_0_28 nbf2_0_27 nbf2_0_28 169000.0
Cbf2_0_28 nbf2_0_28 0 0.02p
Rbf2_0_29 nbf2_0_28 nbf2_0_29 169000.0
Cbf2_0_29 nbf2_0_29 0 0.02p
Rbf2_0_30 nbf2_0_29 nbf2_0_30 169000.0
Cbf2_0_30 nbf2_0_30 0 0.02p
Rbf2_0_31 nbf2_0_30 b 169000.0
Vbf3 bf3in 0 DC 0 AC -0.5
Rbf3_0_0 bf3in nbf3_0_0 169000.0
Cbf3_0_0 nbf3_0_0 0 0.02p
Rbf3_0_1 nbf3_0_0 nbf3_0_1 169000.0
Cbf3_0_1 nbf3_0_1 0 0.02p
Rbf3_0_2 nbf3_0_1 nbf3_0_2 169000.0
Cbf3_0_2 nbf3_0_2 0 0.02p
Rbf3_0_3 nbf3_0_2 nbf3_0_3 169000.0
Cbf3_0_3 nbf3_0_3 0 0.02p
Rbf3_0_4 nbf3_0_3 nbf3_0_4 169000.0
Cbf3_0_4 nbf3_0_4 0 0.02p
Rbf3_0_5 nbf3_0_4 nbf3_0_5 169000.0
Cbf3_0_5 nbf3_0_5 0 0.02p
Rbf3_0_6 nbf3_0_5 nbf3_0_6 169000.0
Cbf3_0_6 nbf3_0_6 0 0.02p
Rbf3_0_7 nbf3_0_6 nbf3_0_7 169000.0
Cbf3_0_7 nbf3_0_7 0 0.02p
Rbf3_0_8 nbf3_0_7 nbf3_0_8 169000.0
Cbf3_0_8 nbf3_0_8 0 0.02p
Rbf3_0_9 nbf3_0_8 nbf3_0_9 169000.0
Cbf3_0_9 nbf3_0_9 0 0.02p
Rbf3_0_10 nbf3_0_9 nbf3_0_10 169000.0
Cbf3_0_10 nbf3_0_10 0 0.02p
Rbf3_0_11 nbf3_0_10 nbf3_0_11 169000.0
Cbf3_0_11 nbf3_0_11 0 0.02p
Rbf3_0_12 nbf3_0_11 nbf3_0_12 169000.0
Cbf3_0_12 nbf3_0_12 0 0.02p
Rbf3_0_13 nbf3_0_12 nbf3_0_13 169000.0
Cbf3_0_13 nbf3_0_13 0 0.02p
Rbf3_0_14 nbf3_0_13 nbf3_0_14 169000.0
Cbf3_0_14 nbf3_0_14 0 0.02p
Rbf3_0_15 nbf3_0_14 b 169000.0
Vbf4 bf4in 0 DC 0 AC -0.5
Rbf4_0_0 bf4in nbf4_0_0 169000.0
Cbf4_0_0 nbf4_0_0 0 0.02p
Rbf4_0_1 nbf4_0_0 nbf4_0_1 169000.0
Cbf4_0_1 nbf4_0_1 0 0.02p
Rbf4_0_2 nbf4_0_1 nbf4_0_2 169000.0
Cbf4_0_2 nbf4_0_2 0 0.02p
Rbf4_0_3 nbf4_0_2 nbf4_0_3 169000.0
Cbf4_0_3 nbf4_0_3 0 0.02p
Rbf4_0_4 nbf4_0_3 nbf4_0_4 169000.0
Cbf4_0_4 nbf4_0_4 0 0.02p
Rbf4_0_5 nbf4_0_4 nbf4_0_5 169000.0
Cbf4_0_5 nbf4_0_5 0 0.02p
Rbf4_0_6 nbf4_0_5 nbf4_0_6 169000.0
Cbf4_0_6 nbf4_0_6 0 0.02p
Rbf4_0_7 nbf4_0_6 b 169000.0
Vbf5 bf5in 0 DC 0 AC -0.5
Rbf5_0_0 bf5in nbf5_0_0 169000.0
Cbf5_0_0 nbf5_0_0 0 0.02p
Rbf5_0_1 nbf5_0_0 nbf5_0_1 169000.0
Cbf5_0_1 nbf5_0_1 0 0.02p
Rbf5_0_2 nbf5_0_1 nbf5_0_2 169000.0
Cbf5_0_2 nbf5_0_2 0 0.02p
Rbf5_0_3 nbf5_0_2 nbf5_0_3 169000.0
Cbf5_0_3 nbf5_0_3 0 0.02p
Rbf5_0_4 nbf5_0_3 nbf5_0_4 169000.0
Cbf5_0_4 nbf5_0_4 0 0.02p
Rbf5_0_5 nbf5_0_4 nbf5_0_5 169000.0
Cbf5_0_5 nbf5_0_5 0 0.02p
Rbf5_0_6 nbf5_0_5 nbf5_0_6 169000.0
Cbf5_0_6 nbf5_0_6 0 0.02p
Rbf5_0_7 nbf5_0_6 b 169000.0
Rbf5_1_0 bf5in nbf5_1_0 169000.0
Cbf5_1_0 nbf5_1_0 0 0.02p
Rbf5_1_1 nbf5_1_0 nbf5_1_1 169000.0
Cbf5_1_1 nbf5_1_1 0 0.02p
Rbf5_1_2 nbf5_1_1 nbf5_1_2 169000.0
Cbf5_1_2 nbf5_1_2 0 0.02p
Rbf5_1_3 nbf5_1_2 nbf5_1_3 169000.0
Cbf5_1_3 nbf5_1_3 0 0.02p
Rbf5_1_4 nbf5_1_3 nbf5_1_4 169000.0
Cbf5_1_4 nbf5_1_4 0 0.02p
Rbf5_1_5 nbf5_1_4 nbf5_1_5 169000.0
Cbf5_1_5 nbf5_1_5 0 0.02p
Rbf5_1_6 nbf5_1_5 nbf5_1_6 169000.0
Cbf5_1_6 nbf5_1_6 0 0.02p
Rbf5_1_7 nbf5_1_6 b 169000.0
Vbf6 bf6in 0 DC 0 AC -0.5
Rbf6_0_0 bf6in nbf6_0_0 169000.0
Cbf6_0_0 nbf6_0_0 0 0.02p
Rbf6_0_1 nbf6_0_0 nbf6_0_1 169000.0
Cbf6_0_1 nbf6_0_1 0 0.02p
Rbf6_0_2 nbf6_0_1 nbf6_0_2 169000.0
Cbf6_0_2 nbf6_0_2 0 0.02p
Rbf6_0_3 nbf6_0_2 nbf6_0_3 169000.0
Cbf6_0_3 nbf6_0_3 0 0.02p
Rbf6_0_4 nbf6_0_3 nbf6_0_4 169000.0
Cbf6_0_4 nbf6_0_4 0 0.02p
Rbf6_0_5 nbf6_0_4 b 169000.0
Rbf6_1_0 bf6in nbf6_1_0 169000.0
Cbf6_1_0 nbf6_1_0 0 0.02p
Rbf6_1_1 nbf6_1_0 nbf6_1_1 169000.0
Cbf6_1_1 nbf6_1_1 0 0.02p
Rbf6_1_2 nbf6_1_1 nbf6_1_2 169000.0
Cbf6_1_2 nbf6_1_2 0 0.02p
Rbf6_1_3 nbf6_1_2 nbf6_1_3 169000.0
Cbf6_1_3 nbf6_1_3 0 0.02p
Rbf6_1_4 nbf6_1_3 nbf6_1_4 169000.0
Cbf6_1_4 nbf6_1_4 0 0.02p
Rbf6_1_5 nbf6_1_4 b 169000.0
Rbf6_2_0 bf6in nbf6_2_0 169000.0
Cbf6_2_0 nbf6_2_0 0 0.02p
Rbf6_2_1 nbf6_2_0 nbf6_2_1 169000.0
Cbf6_2_1 nbf6_2_1 0 0.02p
Rbf6_2_2 nbf6_2_1 nbf6_2_2 169000.0
Cbf6_2_2 nbf6_2_2 0 0.02p
Rbf6_2_3 nbf6_2_2 nbf6_2_3 169000.0
Cbf6_2_3 nbf6_2_3 0 0.02p
Rbf6_2_4 nbf6_2_3 nbf6_2_4 169000.0
Cbf6_2_4 nbf6_2_4 0 0.02p
Rbf6_2_5 nbf6_2_4 b 169000.0
Vbf7 bf7in 0 DC 0 AC -0.5
Rbf7_0_0 bf7in nbf7_0_0 169000.0
Cbf7_0_0 nbf7_0_0 0 0.02p
Rbf7_0_1 nbf7_0_0 nbf7_0_1 169000.0
Cbf7_0_1 nbf7_0_1 0 0.02p
Rbf7_0_2 nbf7_0_1 nbf7_0_2 169000.0
Cbf7_0_2 nbf7_0_2 0 0.02p
Rbf7_0_3 nbf7_0_2 nbf7_0_3 169000.0
Cbf7_0_3 nbf7_0_3 0 0.02p
Rbf7_0_4 nbf7_0_3 nbf7_0_4 169000.0
Cbf7_0_4 nbf7_0_4 0 0.02p
Rbf7_0_5 nbf7_0_4 b 169000.0
Rbf7_1_0 bf7in nbf7_1_0 169000.0
Cbf7_1_0 nbf7_1_0 0 0.02p
Rbf7_1_1 nbf7_1_0 nbf7_1_1 169000.0
Cbf7_1_1 nbf7_1_1 0 0.02p
Rbf7_1_2 nbf7_1_1 nbf7_1_2 169000.0
Cbf7_1_2 nbf7_1_2 0 0.02p
Rbf7_1_3 nbf7_1_2 nbf7_1_3 169000.0
Cbf7_1_3 nbf7_1_3 0 0.02p
Rbf7_1_4 nbf7_1_3 nbf7_1_4 169000.0
Cbf7_1_4 nbf7_1_4 0 0.02p
Rbf7_1_5 nbf7_1_4 b 169000.0
Rbf7_2_0 bf7in nbf7_2_0 169000.0
Cbf7_2_0 nbf7_2_0 0 0.02p
Rbf7_2_1 nbf7_2_0 nbf7_2_1 169000.0
Cbf7_2_1 nbf7_2_1 0 0.02p
Rbf7_2_2 nbf7_2_1 nbf7_2_2 169000.0
Cbf7_2_2 nbf7_2_2 0 0.02p
Rbf7_2_3 nbf7_2_2 nbf7_2_3 169000.0
Cbf7_2_3 nbf7_2_3 0 0.02p
Rbf7_2_4 nbf7_2_3 nbf7_2_4 169000.0
Cbf7_2_4 nbf7_2_4 0 0.02p
Rbf7_2_5 nbf7_2_4 b 169000.0
Rbf7_3_0 bf7in nbf7_3_0 169000.0
Cbf7_3_0 nbf7_3_0 0 0.02p
Rbf7_3_1 nbf7_3_0 nbf7_3_1 169000.0
Cbf7_3_1 nbf7_3_1 0 0.02p
Rbf7_3_2 nbf7_3_1 nbf7_3_2 169000.0
Cbf7_3_2 nbf7_3_2 0 0.02p
Rbf7_3_3 nbf7_3_2 nbf7_3_3 169000.0
Cbf7_3_3 nbf7_3_3 0 0.02p
Rbf7_3_4 nbf7_3_3 nbf7_3_4 169000.0
Cbf7_3_4 nbf7_3_4 0 0.02p
Rbf7_3_5 nbf7_3_4 b 169000.0
Rbf7_4_0 bf7in nbf7_4_0 169000.0
Cbf7_4_0 nbf7_4_0 0 0.02p
Rbf7_4_1 nbf7_4_0 nbf7_4_1 169000.0
Cbf7_4_1 nbf7_4_1 0 0.02p
Rbf7_4_2 nbf7_4_1 nbf7_4_2 169000.0
Cbf7_4_2 nbf7_4_2 0 0.02p
Rbf7_4_3 nbf7_4_2 nbf7_4_3 169000.0
Cbf7_4_3 nbf7_4_3 0 0.02p
Rbf7_4_4 nbf7_4_3 nbf7_4_4 169000.0
Cbf7_4_4 nbf7_4_4 0 0.02p
Rbf7_4_5 nbf7_4_4 b 169000.0
Rbf7_5_0 bf7in nbf7_5_0 169000.0
Cbf7_5_0 nbf7_5_0 0 0.02p
Rbf7_5_1 nbf7_5_0 nbf7_5_1 169000.0
Cbf7_5_1 nbf7_5_1 0 0.02p
Rbf7_5_2 nbf7_5_1 nbf7_5_2 169000.0
Cbf7_5_2 nbf7_5_2 0 0.02p
Rbf7_5_3 nbf7_5_2 nbf7_5_3 169000.0
Cbf7_5_3 nbf7_5_3 0 0.02p
Rbf7_5_4 nbf7_5_3 nbf7_5_4 169000.0
Cbf7_5_4 nbf7_5_4 0 0.02p
Rbf7_5_5 nbf7_5_4 b 169000.0
Vbf8 bf8in 0 DC 0 AC -0.5
Rbf8_0_0 bf8in nbf8_0_0 169000.0
Cbf8_0_0 nbf8_0_0 0 0.02p
Rbf8_0_1 nbf8_0_0 nbf8_0_1 169000.0
Cbf8_0_1 nbf8_0_1 0 0.02p
Rbf8_0_2 nbf8_0_1 nbf8_0_2 169000.0
Cbf8_0_2 nbf8_0_2 0 0.02p
Rbf8_0_3 nbf8_0_2 nbf8_0_3 169000.0
Cbf8_0_3 nbf8_0_3 0 0.02p
Rbf8_0_4 nbf8_0_3 nbf8_0_4 169000.0
Cbf8_0_4 nbf8_0_4 0 0.02p
Rbf8_0_5 nbf8_0_4 b 169000.0
Rbf8_1_0 bf8in nbf8_1_0 169000.0
Cbf8_1_0 nbf8_1_0 0 0.02p
Rbf8_1_1 nbf8_1_0 nbf8_1_1 169000.0
Cbf8_1_1 nbf8_1_1 0 0.02p
Rbf8_1_2 nbf8_1_1 nbf8_1_2 169000.0
Cbf8_1_2 nbf8_1_2 0 0.02p
Rbf8_1_3 nbf8_1_2 nbf8_1_3 169000.0
Cbf8_1_3 nbf8_1_3 0 0.02p
Rbf8_1_4 nbf8_1_3 nbf8_1_4 169000.0
Cbf8_1_4 nbf8_1_4 0 0.02p
Rbf8_1_5 nbf8_1_4 b 169000.0
Rbf8_2_0 bf8in nbf8_2_0 169000.0
Cbf8_2_0 nbf8_2_0 0 0.02p
Rbf8_2_1 nbf8_2_0 nbf8_2_1 169000.0
Cbf8_2_1 nbf8_2_1 0 0.02p
Rbf8_2_2 nbf8_2_1 nbf8_2_2 169000.0
Cbf8_2_2 nbf8_2_2 0 0.02p
Rbf8_2_3 nbf8_2_2 nbf8_2_3 169000.0
Cbf8_2_3 nbf8_2_3 0 0.02p
Rbf8_2_4 nbf8_2_3 nbf8_2_4 169000.0
Cbf8_2_4 nbf8_2_4 0 0.02p
Rbf8_2_5 nbf8_2_4 b 169000.0
Rbf8_3_0 bf8in nbf8_3_0 169000.0
Cbf8_3_0 nbf8_3_0 0 0.02p
Rbf8_3_1 nbf8_3_0 nbf8_3_1 169000.0
Cbf8_3_1 nbf8_3_1 0 0.02p
Rbf8_3_2 nbf8_3_1 nbf8_3_2 169000.0
Cbf8_3_2 nbf8_3_2 0 0.02p
Rbf8_3_3 nbf8_3_2 nbf8_3_3 169000.0
Cbf8_3_3 nbf8_3_3 0 0.02p
Rbf8_3_4 nbf8_3_3 nbf8_3_4 169000.0
Cbf8_3_4 nbf8_3_4 0 0.02p
Rbf8_3_5 nbf8_3_4 b 169000.0
Rbf8_4_0 bf8in nbf8_4_0 169000.0
Cbf8_4_0 nbf8_4_0 0 0.02p
Rbf8_4_1 nbf8_4_0 nbf8_4_1 169000.0
Cbf8_4_1 nbf8_4_1 0 0.02p
Rbf8_4_2 nbf8_4_1 nbf8_4_2 169000.0
Cbf8_4_2 nbf8_4_2 0 0.02p
Rbf8_4_3 nbf8_4_2 nbf8_4_3 169000.0
Cbf8_4_3 nbf8_4_3 0 0.02p
Rbf8_4_4 nbf8_4_3 nbf8_4_4 169000.0
Cbf8_4_4 nbf8_4_4 0 0.02p
Rbf8_4_5 nbf8_4_4 b 169000.0
Rbf8_5_0 bf8in nbf8_5_0 169000.0
Cbf8_5_0 nbf8_5_0 0 0.02p
Rbf8_5_1 nbf8_5_0 nbf8_5_1 169000.0
Cbf8_5_1 nbf8_5_1 0 0.02p
Rbf8_5_2 nbf8_5_1 nbf8_5_2 169000.0
Cbf8_5_2 nbf8_5_2 0 0.02p
Rbf8_5_3 nbf8_5_2 nbf8_5_3 169000.0
Cbf8_5_3 nbf8_5_3 0 0.02p
Rbf8_5_4 nbf8_5_3 nbf8_5_4 169000.0
Cbf8_5_4 nbf8_5_4 0 0.02p
Rbf8_5_5 nbf8_5_4 b 169000.0
Rbf8_6_0 bf8in nbf8_6_0 169000.0
Cbf8_6_0 nbf8_6_0 0 0.02p
Rbf8_6_1 nbf8_6_0 nbf8_6_1 169000.0
Cbf8_6_1 nbf8_6_1 0 0.02p
Rbf8_6_2 nbf8_6_1 nbf8_6_2 169000.0
Cbf8_6_2 nbf8_6_2 0 0.02p
Rbf8_6_3 nbf8_6_2 nbf8_6_3 169000.0
Cbf8_6_3 nbf8_6_3 0 0.02p
Rbf8_6_4 nbf8_6_3 nbf8_6_4 169000.0
Cbf8_6_4 nbf8_6_4 0 0.02p
Rbf8_6_5 nbf8_6_4 b 169000.0
Rbf8_7_0 bf8in nbf8_7_0 169000.0
Cbf8_7_0 nbf8_7_0 0 0.02p
Rbf8_7_1 nbf8_7_0 nbf8_7_1 169000.0
Cbf8_7_1 nbf8_7_1 0 0.02p
Rbf8_7_2 nbf8_7_1 nbf8_7_2 169000.0
Cbf8_7_2 nbf8_7_2 0 0.02p
Rbf8_7_3 nbf8_7_2 nbf8_7_3 169000.0
Cbf8_7_3 nbf8_7_3 0 0.02p
Rbf8_7_4 nbf8_7_3 nbf8_7_4 169000.0
Cbf8_7_4 nbf8_7_4 0 0.02p
Rbf8_7_5 nbf8_7_4 b 169000.0
Rbf8_8_0 bf8in nbf8_8_0 169000.0
Cbf8_8_0 nbf8_8_0 0 0.02p
Rbf8_8_1 nbf8_8_0 nbf8_8_1 169000.0
Cbf8_8_1 nbf8_8_1 0 0.02p
Rbf8_8_2 nbf8_8_1 nbf8_8_2 169000.0
Cbf8_8_2 nbf8_8_2 0 0.02p
Rbf8_8_3 nbf8_8_2 nbf8_8_3 169000.0
Cbf8_8_3 nbf8_8_3 0 0.02p
Rbf8_8_4 nbf8_8_3 nbf8_8_4 169000.0
Cbf8_8_4 nbf8_8_4 0 0.02p
Rbf8_8_5 nbf8_8_4 b 169000.0
Rbf8_9_0 bf8in nbf8_9_0 169000.0
Cbf8_9_0 nbf8_9_0 0 0.02p
Rbf8_9_1 nbf8_9_0 nbf8_9_1 169000.0
Cbf8_9_1 nbf8_9_1 0 0.02p
Rbf8_9_2 nbf8_9_1 nbf8_9_2 169000.0
Cbf8_9_2 nbf8_9_2 0 0.02p
Rbf8_9_3 nbf8_9_2 nbf8_9_3 169000.0
Cbf8_9_3 nbf8_9_3 0 0.02p
Rbf8_9_4 nbf8_9_3 nbf8_9_4 169000.0
Cbf8_9_4 nbf8_9_4 0 0.02p
Rbf8_9_5 nbf8_9_4 b 169000.0
Rbf8_10_0 bf8in nbf8_10_0 169000.0
Cbf8_10_0 nbf8_10_0 0 0.02p
Rbf8_10_1 nbf8_10_0 nbf8_10_1 169000.0
Cbf8_10_1 nbf8_10_1 0 0.02p
Rbf8_10_2 nbf8_10_1 nbf8_10_2 169000.0
Cbf8_10_2 nbf8_10_2 0 0.02p
Rbf8_10_3 nbf8_10_2 nbf8_10_3 169000.0
Cbf8_10_3 nbf8_10_3 0 0.02p
Rbf8_10_4 nbf8_10_3 nbf8_10_4 169000.0
Cbf8_10_4 nbf8_10_4 0 0.02p
Rbf8_10_5 nbf8_10_4 b 169000.0
Rbf8_11_0 bf8in nbf8_11_0 169000.0
Cbf8_11_0 nbf8_11_0 0 0.02p
Rbf8_11_1 nbf8_11_0 nbf8_11_1 169000.0
Cbf8_11_1 nbf8_11_1 0 0.02p
Rbf8_11_2 nbf8_11_1 nbf8_11_2 169000.0
Cbf8_11_2 nbf8_11_2 0 0.02p
Rbf8_11_3 nbf8_11_2 nbf8_11_3 169000.0
Cbf8_11_3 nbf8_11_3 0 0.02p
Rbf8_11_4 nbf8_11_3 nbf8_11_4 169000.0
Cbf8_11_4 nbf8_11_4 0 0.02p
Rbf8_11_5 nbf8_11_4 b 169000.0
Rbterm_0_0 0 nbterm_0_0 169000.0
Cbterm_0_0 nbterm_0_0 0 0.02p
Rbterm_0_1 nbterm_0_0 nbterm_0_1 169000.0
Cbterm_0_1 nbterm_0_1 0 0.02p
Rbterm_0_2 nbterm_0_1 nbterm_0_2 169000.0
Cbterm_0_2 nbterm_0_2 0 0.02p
Rbterm_0_3 nbterm_0_2 nbterm_0_3 169000.0
Cbterm_0_3 nbterm_0_3 0 0.02p
Rbterm_0_4 nbterm_0_3 nbterm_0_4 169000.0
Cbterm_0_4 nbterm_0_4 0 0.02p
Rbterm_0_5 nbterm_0_4 nbterm_0_5 169000.0
Cbterm_0_5 nbterm_0_5 0 0.02p
Rbterm_0_6 nbterm_0_5 nbterm_0_6 169000.0
Cbterm_0_6 nbterm_0_6 0 0.02p
Rbterm_0_7 nbterm_0_6 nbterm_0_7 169000.0
Cbterm_0_7 nbterm_0_7 0 0.02p
Rbterm_0_8 nbterm_0_7 nbterm_0_8 169000.0
Cbterm_0_8 nbterm_0_8 0 0.02p
Rbterm_0_9 nbterm_0_8 nbterm_0_9 169000.0
Cbterm_0_9 nbterm_0_9 0 0.02p
Rbterm_0_10 nbterm_0_9 nbterm_0_10 169000.0
Cbterm_0_10 nbterm_0_10 0 0.02p
Rbterm_0_11 nbterm_0_10 nbterm_0_11 169000.0
Cbterm_0_11 nbterm_0_11 0 0.02p
Rbterm_0_12 nbterm_0_11 nbterm_0_12 169000.0
Cbterm_0_12 nbterm_0_12 0 0.02p
Rbterm_0_13 nbterm_0_12 nbterm_0_13 169000.0
Cbterm_0_13 nbterm_0_13 0 0.02p
Rbterm_0_14 nbterm_0_13 nbterm_0_14 169000.0
Cbterm_0_14 nbterm_0_14 0 0.02p
Rbterm_0_15 nbterm_0_14 nbterm_0_15 169000.0
Cbterm_0_15 nbterm_0_15 0 0.02p
Rbterm_0_16 nbterm_0_15 nbterm_0_16 169000.0
Cbterm_0_16 nbterm_0_16 0 0.02p
Rbterm_0_17 nbterm_0_16 nbterm_0_17 169000.0
Cbterm_0_17 nbterm_0_17 0 0.02p
Rbterm_0_18 nbterm_0_17 nbterm_0_18 169000.0
Cbterm_0_18 nbterm_0_18 0 0.02p
Rbterm_0_19 nbterm_0_18 nbterm_0_19 169000.0
Cbterm_0_19 nbterm_0_19 0 0.02p
Rbterm_0_20 nbterm_0_19 nbterm_0_20 169000.0
Cbterm_0_20 nbterm_0_20 0 0.02p
Rbterm_0_21 nbterm_0_20 nbterm_0_21 169000.0
Cbterm_0_21 nbterm_0_21 0 0.02p
Rbterm_0_22 nbterm_0_21 nbterm_0_22 169000.0
Cbterm_0_22 nbterm_0_22 0 0.02p
Rbterm_0_23 nbterm_0_22 nbterm_0_23 169000.0
Cbterm_0_23 nbterm_0_23 0 0.02p
Rbterm_0_24 nbterm_0_23 nbterm_0_24 169000.0
Cbterm_0_24 nbterm_0_24 0 0.02p
Rbterm_0_25 nbterm_0_24 nbterm_0_25 169000.0
Cbterm_0_25 nbterm_0_25 0 0.02p
Rbterm_0_26 nbterm_0_25 nbterm_0_26 169000.0
Cbterm_0_26 nbterm_0_26 0 0.02p
Rbterm_0_27 nbterm_0_26 nbterm_0_27 169000.0
Cbterm_0_27 nbterm_0_27 0 0.02p
Rbterm_0_28 nbterm_0_27 nbterm_0_28 169000.0
Cbterm_0_28 nbterm_0_28 0 0.02p
Rbterm_0_29 nbterm_0_28 nbterm_0_29 169000.0
Cbterm_0_29 nbterm_0_29 0 0.02p
Rbterm_0_30 nbterm_0_29 nbterm_0_30 169000.0
Cbterm_0_30 nbterm_0_30 0 0.02p
Rbterm_0_31 nbterm_0_30 nbterm_0_31 169000.0
Cbterm_0_31 nbterm_0_31 0 0.02p
Rbterm_0_32 nbterm_0_31 nbterm_0_32 169000.0
Cbterm_0_32 nbterm_0_32 0 0.02p
Rbterm_0_33 nbterm_0_32 nbterm_0_33 169000.0
Cbterm_0_33 nbterm_0_33 0 0.02p
Rbterm_0_34 nbterm_0_33 nbterm_0_34 169000.0
Cbterm_0_34 nbterm_0_34 0 0.02p
Rbterm_0_35 nbterm_0_34 nbterm_0_35 169000.0
Cbterm_0_35 nbterm_0_35 0 0.02p
Rbterm_0_36 nbterm_0_35 nbterm_0_36 169000.0
Cbterm_0_36 nbterm_0_36 0 0.02p
Rbterm_0_37 nbterm_0_36 nbterm_0_37 169000.0
Cbterm_0_37 nbterm_0_37 0 0.02p
Rbterm_0_38 nbterm_0_37 nbterm_0_38 169000.0
Cbterm_0_38 nbterm_0_38 0 0.02p
Rbterm_0_39 nbterm_0_38 nbterm_0_39 169000.0
Cbterm_0_39 nbterm_0_39 0 0.02p
Rbterm_0_40 nbterm_0_39 nbterm_0_40 169000.0
Cbterm_0_40 nbterm_0_40 0 0.02p
Rbterm_0_41 nbterm_0_40 nbterm_0_41 169000.0
Cbterm_0_41 nbterm_0_41 0 0.02p
Rbterm_0_42 nbterm_0_41 nbterm_0_42 169000.0
Cbterm_0_42 nbterm_0_42 0 0.02p
Rbterm_0_43 nbterm_0_42 nbterm_0_43 169000.0
Cbterm_0_43 nbterm_0_43 0 0.02p
Rbterm_0_44 nbterm_0_43 nbterm_0_44 169000.0
Cbterm_0_44 nbterm_0_44 0 0.02p
Rbterm_0_45 nbterm_0_44 nbterm_0_45 169000.0
Cbterm_0_45 nbterm_0_45 0 0.02p
Rbterm_0_46 nbterm_0_45 nbterm_0_46 169000.0
Cbterm_0_46 nbterm_0_46 0 0.02p
Rbterm_0_47 nbterm_0_46 nbterm_0_47 169000.0
Cbterm_0_47 nbterm_0_47 0 0.02p
Rbterm_0_48 nbterm_0_47 nbterm_0_48 169000.0
Cbterm_0_48 nbterm_0_48 0 0.02p
Rbterm_0_49 nbterm_0_48 nbterm_0_49 169000.0
Cbterm_0_49 nbterm_0_49 0 0.02p
Rbterm_0_50 nbterm_0_49 nbterm_0_50 169000.0
Cbterm_0_50 nbterm_0_50 0 0.02p
Rbterm_0_51 nbterm_0_50 nbterm_0_51 169000.0
Cbterm_0_51 nbterm_0_51 0 0.02p
Rbterm_0_52 nbterm_0_51 nbterm_0_52 169000.0
Cbterm_0_52 nbterm_0_52 0 0.02p
Rbterm_0_53 nbterm_0_52 nbterm_0_53 169000.0
Cbterm_0_53 nbterm_0_53 0 0.02p
Rbterm_0_54 nbterm_0_53 nbterm_0_54 169000.0
Cbterm_0_54 nbterm_0_54 0 0.02p
Rbterm_0_55 nbterm_0_54 nbterm_0_55 169000.0
Cbterm_0_55 nbterm_0_55 0 0.02p
Rbterm_0_56 nbterm_0_55 nbterm_0_56 169000.0
Cbterm_0_56 nbterm_0_56 0 0.02p
Rbterm_0_57 nbterm_0_56 nbterm_0_57 169000.0
Cbterm_0_57 nbterm_0_57 0 0.02p
Rbterm_0_58 nbterm_0_57 nbterm_0_58 169000.0
Cbterm_0_58 nbterm_0_58 0 0.02p
Rbterm_0_59 nbterm_0_58 nbterm_0_59 169000.0
Cbterm_0_59 nbterm_0_59 0 0.02p
Rbterm_0_60 nbterm_0_59 nbterm_0_60 169000.0
Cbterm_0_60 nbterm_0_60 0 0.02p
Rbterm_0_61 nbterm_0_60 nbterm_0_61 169000.0
Cbterm_0_61 nbterm_0_61 0 0.02p
Rbterm_0_62 nbterm_0_61 nbterm_0_62 169000.0
Cbterm_0_62 nbterm_0_62 0 0.02p
Rbterm_0_63 nbterm_0_62 nbterm_0_63 169000.0
Cbterm_0_63 nbterm_0_63 0 0.02p
Rbterm_0_64 nbterm_0_63 nbterm_0_64 169000.0
Cbterm_0_64 nbterm_0_64 0 0.02p
Rbterm_0_65 nbterm_0_64 nbterm_0_65 169000.0
Cbterm_0_65 nbterm_0_65 0 0.02p
Rbterm_0_66 nbterm_0_65 nbterm_0_66 169000.0
Cbterm_0_66 nbterm_0_66 0 0.02p
Rbterm_0_67 nbterm_0_66 nbterm_0_67 169000.0
Cbterm_0_67 nbterm_0_67 0 0.02p
Rbterm_0_68 nbterm_0_67 nbterm_0_68 169000.0
Cbterm_0_68 nbterm_0_68 0 0.02p
Rbterm_0_69 nbterm_0_68 nbterm_0_69 169000.0
Cbterm_0_69 nbterm_0_69 0 0.02p
Rbterm_0_70 nbterm_0_69 nbterm_0_70 169000.0
Cbterm_0_70 nbterm_0_70 0 0.02p
Rbterm_0_71 nbterm_0_70 nbterm_0_71 169000.0
Cbterm_0_71 nbterm_0_71 0 0.02p
Rbterm_0_72 nbterm_0_71 nbterm_0_72 169000.0
Cbterm_0_72 nbterm_0_72 0 0.02p
Rbterm_0_73 nbterm_0_72 nbterm_0_73 169000.0
Cbterm_0_73 nbterm_0_73 0 0.02p
Rbterm_0_74 nbterm_0_73 nbterm_0_74 169000.0
Cbterm_0_74 nbterm_0_74 0 0.02p
Rbterm_0_75 nbterm_0_74 nbterm_0_75 169000.0
Cbterm_0_75 nbterm_0_75 0 0.02p
Rbterm_0_76 nbterm_0_75 nbterm_0_76 169000.0
Cbterm_0_76 nbterm_0_76 0 0.02p
Rbterm_0_77 nbterm_0_76 nbterm_0_77 169000.0
Cbterm_0_77 nbterm_0_77 0 0.02p
Rbterm_0_78 nbterm_0_77 nbterm_0_78 169000.0
Cbterm_0_78 nbterm_0_78 0 0.02p
Rbterm_0_79 nbterm_0_78 nbterm_0_79 169000.0
Cbterm_0_79 nbterm_0_79 0 0.02p
Rbterm_0_80 nbterm_0_79 nbterm_0_80 169000.0
Cbterm_0_80 nbterm_0_80 0 0.02p
Rbterm_0_81 nbterm_0_80 nbterm_0_81 169000.0
Cbterm_0_81 nbterm_0_81 0 0.02p
Rbterm_0_82 nbterm_0_81 nbterm_0_82 169000.0
Cbterm_0_82 nbterm_0_82 0 0.02p
Rbterm_0_83 nbterm_0_82 nbterm_0_83 169000.0
Cbterm_0_83 nbterm_0_83 0 0.02p
Rbterm_0_84 nbterm_0_83 nbterm_0_84 169000.0
Cbterm_0_84 nbterm_0_84 0 0.02p
Rbterm_0_85 nbterm_0_84 nbterm_0_85 169000.0
Cbterm_0_85 nbterm_0_85 0 0.02p
Rbterm_0_86 nbterm_0_85 nbterm_0_86 169000.0
Cbterm_0_86 nbterm_0_86 0 0.02p
Rbterm_0_87 nbterm_0_86 nbterm_0_87 169000.0
Cbterm_0_87 nbterm_0_87 0 0.02p
Rbterm_0_88 nbterm_0_87 nbterm_0_88 169000.0
Cbterm_0_88 nbterm_0_88 0 0.02p
Rbterm_0_89 nbterm_0_88 nbterm_0_89 169000.0
Cbterm_0_89 nbterm_0_89 0 0.02p
Rbterm_0_90 nbterm_0_89 nbterm_0_90 169000.0
Cbterm_0_90 nbterm_0_90 0 0.02p
Rbterm_0_91 nbterm_0_90 nbterm_0_91 169000.0
Cbterm_0_91 nbterm_0_91 0 0.02p
Rbterm_0_92 nbterm_0_91 nbterm_0_92 169000.0
Cbterm_0_92 nbterm_0_92 0 0.02p
Rbterm_0_93 nbterm_0_92 nbterm_0_93 169000.0
Cbterm_0_93 nbterm_0_93 0 0.02p
Rbterm_0_94 nbterm_0_93 nbterm_0_94 169000.0
Cbterm_0_94 nbterm_0_94 0 0.02p
Rbterm_0_95 nbterm_0_94 nbterm_0_95 169000.0
Cbterm_0_95 nbterm_0_95 0 0.02p
Rbterm_0_96 nbterm_0_95 nbterm_0_96 169000.0
Cbterm_0_96 nbterm_0_96 0 0.02p
Rbterm_0_97 nbterm_0_96 nbterm_0_97 169000.0
Cbterm_0_97 nbterm_0_97 0 0.02p
Rbterm_0_98 nbterm_0_97 nbterm_0_98 169000.0
Cbterm_0_98 nbterm_0_98 0 0.02p
Rbterm_0_99 nbterm_0_98 nbterm_0_99 169000.0
Cbterm_0_99 nbterm_0_99 0 0.02p
Rbterm_0_100 nbterm_0_99 nbterm_0_100 169000.0
Cbterm_0_100 nbterm_0_100 0 0.02p
Rbterm_0_101 nbterm_0_100 nbterm_0_101 169000.0
Cbterm_0_101 nbterm_0_101 0 0.02p
Rbterm_0_102 nbterm_0_101 nbterm_0_102 169000.0
Cbterm_0_102 nbterm_0_102 0 0.02p
Rbterm_0_103 nbterm_0_102 nbterm_0_103 169000.0
Cbterm_0_103 nbterm_0_103 0 0.02p
Rbterm_0_104 nbterm_0_103 nbterm_0_104 169000.0
Cbterm_0_104 nbterm_0_104 0 0.02p
Rbterm_0_105 nbterm_0_104 nbterm_0_105 169000.0
Cbterm_0_105 nbterm_0_105 0 0.02p
Rbterm_0_106 nbterm_0_105 nbterm_0_106 169000.0
Cbterm_0_106 nbterm_0_106 0 0.02p
Rbterm_0_107 nbterm_0_106 nbterm_0_107 169000.0
Cbterm_0_107 nbterm_0_107 0 0.02p
Rbterm_0_108 nbterm_0_107 nbterm_0_108 169000.0
Cbterm_0_108 nbterm_0_108 0 0.02p
Rbterm_0_109 nbterm_0_108 nbterm_0_109 169000.0
Cbterm_0_109 nbterm_0_109 0 0.02p
Rbterm_0_110 nbterm_0_109 nbterm_0_110 169000.0
Cbterm_0_110 nbterm_0_110 0 0.02p
Rbterm_0_111 nbterm_0_110 nbterm_0_111 169000.0
Cbterm_0_111 nbterm_0_111 0 0.02p
Rbterm_0_112 nbterm_0_111 nbterm_0_112 169000.0
Cbterm_0_112 nbterm_0_112 0 0.02p
Rbterm_0_113 nbterm_0_112 nbterm_0_113 169000.0
Cbterm_0_113 nbterm_0_113 0 0.02p
Rbterm_0_114 nbterm_0_113 nbterm_0_114 169000.0
Cbterm_0_114 nbterm_0_114 0 0.02p
Rbterm_0_115 nbterm_0_114 nbterm_0_115 169000.0
Cbterm_0_115 nbterm_0_115 0 0.02p
Rbterm_0_116 nbterm_0_115 nbterm_0_116 169000.0
Cbterm_0_116 nbterm_0_116 0 0.02p
Rbterm_0_117 nbterm_0_116 nbterm_0_117 169000.0
Cbterm_0_117 nbterm_0_117 0 0.02p
Rbterm_0_118 nbterm_0_117 nbterm_0_118 169000.0
Cbterm_0_118 nbterm_0_118 0 0.02p
Rbterm_0_119 nbterm_0_118 nbterm_0_119 169000.0
Cbterm_0_119 nbterm_0_119 0 0.02p
Rbterm_0_120 nbterm_0_119 nbterm_0_120 169000.0
Cbterm_0_120 nbterm_0_120 0 0.02p
Rbterm_0_121 nbterm_0_120 nbterm_0_121 169000.0
Cbterm_0_121 nbterm_0_121 0 0.02p
Rbterm_0_122 nbterm_0_121 nbterm_0_122 169000.0
Cbterm_0_122 nbterm_0_122 0 0.02p
Rbterm_0_123 nbterm_0_122 nbterm_0_123 169000.0
Cbterm_0_123 nbterm_0_123 0 0.02p
Rbterm_0_124 nbterm_0_123 nbterm_0_124 169000.0
Cbterm_0_124 nbterm_0_124 0 0.02p
Rbterm_0_125 nbterm_0_124 nbterm_0_125 169000.0
Cbterm_0_125 nbterm_0_125 0 0.02p
Rbterm_0_126 nbterm_0_125 nbterm_0_126 169000.0
Cbterm_0_126 nbterm_0_126 0 0.02p
Rbterm_0_127 nbterm_0_126 b 169000.0
Rload a b 10000
.save v(a) v(b)
.ac dec 50 10 1000000
.end
