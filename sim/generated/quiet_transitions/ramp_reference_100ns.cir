Audio quiet ramp / 5V / skew 0 ns / tolerance 0
Vref ref 0 5
.options reltol=1e-8 abstol=1e-14 method=gear
Va srca 0 PWL(0 2.5 5.2e-06 2.5 5.202e-06 2.5048828125 1.042e-05 2.5048828125 1.0422e-05 2.510986328125 1.562e-05 2.510986328125 1.5622e-05 2.51708984375 2.084e-05 2.51708984375 2.0842e-05 2.523193359375 2.604e-05 2.523193359375 2.6042e-05 2.528076171875 3.124e-05 2.528076171875 3.1242e-05 2.5341796875 3.646e-05 2.5341796875 3.6462e-05 2.5390625 4.166e-05 2.5390625 4.1662e-05 2.545166015625 4.688e-05 2.545166015625 4.6882e-05 2.550048828125 5.208e-05 2.550048828125 5.2082e-05 2.554931640625 5.73e-05 2.554931640625 5.7302e-05 2.559814453125 6.25e-05 2.559814453125 6.2502e-05 2.564697265625 6.77e-05 2.564697265625 6.7702e-05 2.568359375 7.292e-05 2.568359375 7.2922e-05 2.5732421875 7.812e-05 2.5732421875 7.8122e-05 2.576904296875 8.334e-05 2.576904296875 8.3342e-05 2.58056640625 8.854e-05 2.58056640625 8.8542e-05 2.584228515625 9.376e-05 2.584228515625 9.3762e-05 2.586669921875 9.896e-05 2.586669921875 9.8962e-05 2.59033203125 0.00010416 2.59033203125 0.000104162 2.5927734375 0.00010938 2.5927734375 0.000109382 2.593994140625 0.00011458 2.593994140625 0.000114582 2.596435546875 0.0001198 2.596435546875 0.000119802 2.59765625 0.000125 2.59765625 0.000125002 2.598876953125 0.0001302 2.598876953125 0.000130202 2.60009765625 0.00014584 2.60009765625 0.000145842 2.598876953125 0.00015624 2.598876953125 0.000156242 2.596435546875 0.00016146 2.596435546875 0.000161462 2.59521484375 0.00016666 2.59521484375 0.000166662 2.5927734375 0.00017188 2.5927734375 0.000171882 2.59033203125 0.00017708 2.59033203125 0.000177082 2.587890625 0.0001823 2.587890625 0.000182302 2.584228515625 0.0001875 2.584228515625 0.000187502 2.58056640625 0.0001927 2.58056640625 0.000192702 2.57568359375 0.00019792 2.57568359375 0.000197922 2.57080078125 0.00020312 2.57080078125 0.000203122 2.56591796875 0.00020834 2.56591796875 0.000208342 2.559814453125 0.00021354 2.559814453125 0.000213542 2.5537109375 0.00021876 2.5537109375 0.000218762 2.547607421875 0.00022396 2.547607421875 0.000223962 2.540283203125 0.00022916 2.540283203125 0.000229162 2.532958984375 0.00023438 2.532958984375 0.000234382 2.525634765625 0.00023958 2.525634765625 0.000239582 2.51708984375 0.0002448 2.51708984375 0.000244802 2.508544921875 0.00025 2.508544921875 0.000250002 2.5 0.0002552 2.5 0.000255202 2.490234375 0.00026042 2.490234375 0.000260422 2.48046875 0.00026562 2.48046875 0.000265622 2.470703125 0.00027084 2.470703125 0.000270842 2.459716796875 0.00027604 2.459716796875 0.000276042 2.44873046875 0.00028124 2.44873046875 0.000281242 2.437744140625 0.00028646 2.437744140625 0.000286462 2.4267578125 0.00029166 2.4267578125 0.000291662 2.41455078125 0.00029688 2.41455078125 0.000296882 2.40234375 0.00030208 2.40234375 0.000302082 2.39013671875 0.0003073 2.39013671875 0.000307302 2.3779296875 0.0003125 2.3779296875 0.000312502 2.364501953125 0.0003177 2.364501953125 0.000317702 2.352294921875 0.00032292 2.352294921875 0.000322922 2.3388671875 0.00032812 2.3388671875 0.000328122 2.325439453125 0.00033334 2.325439453125 0.000333342 2.31201171875 0.00033854 2.31201171875 0.000338542 2.298583984375 0.00034376 2.298583984375 0.000343762 2.28515625 0.00034896 2.28515625 0.000348962 2.2705078125 0.00035416 2.2705078125 0.000354162 2.257080078125 0.00035938 2.257080078125 0.000359382 2.242431640625 0.00036458 2.242431640625 0.000364582 2.22900390625 0.0003698 2.22900390625 0.000369802 2.215576171875 0.000375 2.215576171875 0.000375002 2.200927734375 0.0003802 2.200927734375 0.000380202 2.1875 0.00038542 2.1875 0.000385422 2.174072265625 0.00039062 2.174072265625 0.000390622 2.159423828125 0.00039584 2.159423828125 0.000395842 2.14599609375 0.00040104 2.14599609375 0.000401042 2.132568359375 0.00040624 2.132568359375 0.000406242 2.119140625 0.00041146 2.119140625 0.000411462 2.10693359375 0.00041666 2.10693359375 0.000416662 2.093505859375 0.00042188 2.093505859375 0.000421882 2.081298828125 0.00042708 2.081298828125 0.000427082 2.069091796875 0.0004323 2.069091796875 0.000432302 2.056884765625 0.0004375 2.056884765625 0.000437502 2.044677734375 0.0004427 2.044677734375 0.000442702 2.03369140625 0.00044792 2.03369140625 0.000447922 2.022705078125 0.00045312 2.022705078125 0.000453122 2.01171875 0.00045834 2.01171875 0.000458342 2.001953125 0.00046354 2.001953125 0.000463542 1.9921875 0.00046876 1.9921875 0.000468762 1.982421875 0.00047396 1.982421875 0.000473962 1.973876953125 0.00047916 1.973876953125 0.000479162 1.96533203125 0.00048438 1.96533203125 0.000484382 1.956787109375 0.00048958 1.956787109375 0.000489582 1.949462890625 0.0004948 1.949462890625 0.000494802 1.943359375 0.0005 1.943359375 0.000500002 1.937255859375 0.0005052 1.937255859375 0.000505202 1.93115234375 0.00051042 1.93115234375 0.000510422 1.92626953125 0.00051562 1.92626953125 0.000515622 1.922607421875 0.00052084 1.922607421875 0.000520842 1.9189453125 0.00052604 1.9189453125 0.000526042 1.915283203125 0.00053126 1.915283203125 0.000531262 1.912841796875 0.00053646 1.912841796875 0.000536462 1.91162109375 0.00054166 1.91162109375 0.000541662 1.910400390625 0.00055208 1.910400390625 0.000552082 1.91162109375 0.0005573 1.91162109375 0.000557302 1.912841796875 0.0005625 1.912841796875 0.000562502 1.915283203125 0.0005677 1.915283203125 0.000567702 1.917724609375 0.00057292 1.917724609375 0.000572922 1.92138671875 0.00057812 1.92138671875 0.000578122 1.92626953125 0.00058334 1.92626953125 0.000583342 1.93115234375 0.00058854 1.93115234375 0.000588542 1.937255859375 0.00059376 1.937255859375 0.000593762 1.944580078125 0.00059896 1.944580078125 0.000598962 1.951904296875 0.00060416 1.951904296875 0.000604162 1.96044921875 0.00060938 1.96044921875 0.000609382 1.968994140625 0.00061458 1.968994140625 0.000614582 1.97998046875 0.0006198 1.97998046875 0.000619802 1.990966796875 0.000625 1.990966796875 0.000625002 2.001953125 0.0006302 2.001953125 0.000630202 2.015380859375 0.00063542 2.015380859375 0.000635422 2.027587890625 0.00064062 2.027587890625 0.000640622 2.042236328125 0.00064584 2.042236328125 0.000645842 2.056884765625 0.00065104 2.056884765625 0.000651042 2.07275390625 0.00065624 2.07275390625 0.000656242 2.08984375 0.00066146 2.08984375 0.000661462 2.10693359375 0.00066666 2.10693359375 0.000666662 2.1240234375 0.00067188 2.1240234375 0.000671882 2.1435546875 0.00067708 2.1435546875 0.000677082 2.1630859375 0.0006823 2.1630859375 0.000682302 2.1826171875 0.0006875 2.1826171875 0.000687502 2.203369140625 0.0006927 2.203369140625 0.000692702 2.225341796875 0.00069792 2.225341796875 0.000697922 2.247314453125 0.00070312 2.247314453125 0.000703122 2.269287109375 0.00070834 2.269287109375 0.000708342 2.293701171875 0.00071354 2.293701171875 0.000713542 2.31689453125 0.00071876 2.31689453125 0.000718762 2.34130859375 0.00072396 2.34130859375 0.000723962 2.366943359375 0.00072916 2.366943359375 0.000729162 2.392578125 0.00073438 2.392578125 0.000734382 2.418212890625 0.00073958 2.418212890625 0.000739582 2.445068359375 0.0007448 2.445068359375 0.000744802 2.471923828125 0.00075 2.471923828125 0.000750002 2.498779296875 0.0007552 2.498779296875 0.000755202 2.52685546875 0.00076042 2.52685546875 0.000760422 2.554931640625 0.00076562 2.554931640625 0.000765622 2.584228515625 0.00077084 2.584228515625 0.000770842 2.6123046875 0.00077604 2.6123046875 0.000776042 2.6416015625 0.00078124 2.6416015625 0.000781242 2.6708984375 0.00078646 2.6708984375 0.000786462 2.7001953125 0.00079166 2.7001953125 0.000791662 2.7294921875 0.00079688 2.7294921875 0.000796882 2.760009765625 0.00080208 2.760009765625 0.000802082 2.789306640625 0.0008073 2.789306640625 0.000807302 2.81982421875 0.0008125 2.81982421875 0.000812502 2.84912109375 0.0008177 2.84912109375 0.000817702 2.87841796875 0.00082292 2.87841796875 0.000822922 2.908935546875 0.00082812 2.908935546875 0.000828122 2.938232421875 0.00083334 2.938232421875 0.000833342 2.967529296875 0.00083854 2.967529296875 0.000838542 2.996826171875 0.00084376 2.996826171875 0.000843762 3.026123046875 0.00084896 3.026123046875 0.000848962 3.055419921875 0.00085416 3.055419921875 0.000854162 3.084716796875 0.00085938 3.084716796875 0.000859382 3.11279296875 0.00086458 3.11279296875 0.000864582 3.140869140625 0.0008698 3.140869140625 0.000869802 3.167724609375 0.000875 3.167724609375 0.000875002 3.19580078125 0.0008802 3.19580078125 0.000880202 3.221435546875 0.00088542 3.221435546875 0.000885422 3.248291015625 0.00089062 3.248291015625 0.000890622 3.27392578125 0.00089584 3.27392578125 0.000895842 3.29833984375 0.00090104 3.29833984375 0.000901042 3.32275390625 0.00090624 3.32275390625 0.000906242 3.34716796875 0.00091146 3.34716796875 0.000911462 3.370361328125 0.00091666 3.370361328125 0.000916662 3.392333984375 0.00092188 3.392333984375 0.000921882 3.414306640625 0.00092708 3.414306640625 0.000927082 3.43505859375 0.0009323 3.43505859375 0.000932302 3.45458984375 0.0009375 3.45458984375 0.000937502 3.47412109375 0.0009427 3.47412109375 0.000942702 3.4912109375 0.00094792 3.4912109375 0.000947922 3.509521484375 0.00095312 3.509521484375 0.000953122 3.525390625 0.00095834 3.525390625 0.000958342 3.5400390625 0.00096354 3.5400390625 0.000963542 3.5546875 0.00096876 3.5546875 0.000968762 3.568115234375 0.00097396 3.568115234375 0.000973962 3.580322265625 0.00097916 3.580322265625 0.000979162 3.59130859375 0.00098438 3.59130859375 0.000984382 3.60107421875 0.00098958 3.60107421875 0.000989582 3.609619140625 0.0009948 3.609619140625 0.000994802 3.6181640625 0.001 3.6181640625 0.001000002 3.624267578125 0.0010052 3.624267578125 0.001005202 3.629150390625 0.00101042 3.629150390625 0.001010422 3.6328125 0.00101562 3.6328125 0.001015622 3.636474609375 0.00102084 3.636474609375 0.001020842 3.6376953125 0.00103124 3.6376953125 0.001031242 3.636474609375 0.00103646 3.636474609375 0.001036462 3.63525390625 0.00104166 3.63525390625 0.001041662 3.631591796875 0.00104688 3.631591796875 0.001046882 3.626708984375 0.00105208 3.626708984375 0.001052082 3.619384765625 0.0010573 3.619384765625 0.001057302 3.612060546875 0.0010625 3.612060546875 0.001062502 3.603515625 0.0010677 3.603515625 0.001067702 3.59375 0.00107292 3.59375 0.001072922 3.58154296875 0.00107812 3.58154296875 0.001078122 3.5693359375 0.00108334 3.5693359375 0.001083342 3.5546875 0.00108854 3.5546875 0.001088542 3.538818359375 0.00109376 3.538818359375 0.001093762 3.521728515625 0.00109896 3.521728515625 0.001098962 3.504638671875 0.00110416 3.504638671875 0.001104162 3.485107421875 0.00110938 3.485107421875 0.001109382 3.46435546875 0.00111458 3.46435546875 0.001114582 3.4423828125 0.0011198 3.4423828125 0.001119802 3.419189453125 0.001125 3.419189453125 0.001125002 3.3935546875 0.0011302 3.3935546875 0.001130202 3.367919921875 0.00113542 3.367919921875 0.001135422 3.341064453125 0.00114062 3.341064453125 0.001140622 3.31298828125 0.00114584 3.31298828125 0.001145842 3.28369140625 0.00115104 3.28369140625 0.001151042 3.253173828125 0.00115624 3.253173828125 0.001156242 3.221435546875 0.00116146 3.221435546875 0.001161462 3.189697265625 0.00116666 3.189697265625 0.001166662 3.155517578125 0.00117188 3.155517578125 0.001171882 3.1201171875 0.00117708 3.1201171875 0.001177082 3.084716796875 0.0011823 3.084716796875 0.001182302 3.048095703125 0.0011875 3.048095703125 0.001187502 3.01025390625 0.0011927 3.01025390625 0.001192702 2.972412109375 0.00119792 2.972412109375 0.001197922 2.93212890625 0.00120312 2.93212890625 0.001203122 2.891845703125 0.00120834 2.891845703125 0.001208342 2.8515625 0.00121354 2.8515625 0.001213542 2.808837890625 0.00121876 2.808837890625 0.001218762 2.767333984375 0.00122396 2.767333984375 0.001223962 2.723388671875 0.00122916 2.723388671875 0.001229162 2.679443359375 0.00123438 2.679443359375 0.001234382 2.635498046875 0.00123958 2.635498046875 0.001239582 2.59033203125 0.0012448 2.59033203125 0.001244802 2.545166015625 0.00125 2.545166015625 0.001250002 2.5 0.0012552 2.5 0.001255202 2.45361328125 0.00126042 2.45361328125 0.001260422 2.4072265625 0.00126562 2.4072265625 0.001265622 2.359619140625 0.00127084 2.359619140625 0.001270842 2.313232421875 0.00127604 2.313232421875 0.001276042 2.265625 0.00128124 2.265625 0.001281242 2.218017578125 0.00128646 2.218017578125 0.001286462 2.17041015625 0.00129166 2.17041015625 0.001291662 2.1240234375 0.00129688 2.1240234375 0.001296882 2.076416015625 0.00130208 2.076416015625 0.001302082 2.02880859375 0.0013073 2.02880859375 0.001307302 1.981201171875 0.0013125 1.981201171875 0.001312502 1.934814453125 0.0013177 1.934814453125 0.001317702 1.88720703125 0.00132292 1.88720703125 0.001322922 1.8408203125 0.00132812 1.8408203125 0.001328122 1.795654296875 0.00133334 1.795654296875 0.001333342 1.749267578125 0.00133854 1.749267578125 0.001338542 1.7041015625 0.00134376 1.7041015625 0.001343762 1.66015625 0.00134896 1.66015625 0.001348962 1.6162109375 0.00135416 1.6162109375 0.001354162 1.572265625 0.00135938 1.572265625 0.001359382 1.529541015625 0.00136458 1.529541015625 0.001364582 1.488037109375 0.0013698 1.488037109375 0.001369802 1.446533203125 0.001375 1.446533203125 0.001375002 1.40625 0.0013802 1.40625 0.001380202 1.365966796875 0.00138542 1.365966796875 0.001385422 1.328125 0.00139062 1.328125 0.001390622 1.290283203125 0.00139584 1.290283203125 0.001395842 1.253662109375 0.00140104 1.253662109375 0.001401042 1.21826171875 0.00140624 1.21826171875 0.001406242 1.18408203125 0.00141146 1.18408203125 0.001411462 1.151123046875 0.00141666 1.151123046875 0.001416662 1.119384765625 0.00142188 1.119384765625 0.001421882 1.0888671875 0.00142708 1.0888671875 0.001427082 1.0595703125 0.0014323 1.0595703125 0.001432302 1.031494140625 0.0014375 1.031494140625 0.001437502 1.005859375 0.0014427 1.005859375 0.001442702 0.980224609375 0.00144792 0.980224609375 0.001447922 0.95703125 0.00145312 0.95703125 0.001453122 0.93505859375 0.00145834 0.93505859375 0.001458342 0.91552734375 0.00146354 0.91552734375 0.001463542 0.89599609375 0.00146876 0.89599609375 0.001468762 0.87890625 0.00147396 0.87890625 0.001473962 0.8642578125 0.00147916 0.8642578125 0.001479162 0.849609375 0.00148438 0.849609375 0.001484382 0.83740234375 0.00148958 0.83740234375 0.001489582 0.82763671875 0.0014948 0.82763671875 0.001494802 0.819091796875 0.0015 0.819091796875 0.001500002 0.811767578125 0.0015052 0.811767578125 0.001505202 0.806884765625 0.00151042 0.806884765625 0.001510422 0.804443359375 0.00151562 0.804443359375 0.001515622 0.80322265625 0.00152604 0.80322265625 0.001526042 0.8056640625 0.00153124 0.8056640625 0.001531242 0.810546875 0.00153646 0.810546875 0.001536462 0.816650390625 0.00154166 0.816650390625 0.001541662 0.823974609375 0.00154688 0.823974609375 0.001546882 0.8349609375 0.00155208 0.8349609375 0.001552082 0.845947265625 0.0015573 0.845947265625 0.001557302 0.860595703125 0.0015625 0.860595703125 0.001562502 0.875244140625 0.0015677 0.875244140625 0.001567702 0.8935546875 0.00157292 0.8935546875 0.001572922 0.9130859375 0.00157812 0.9130859375 0.001578122 0.933837890625 0.00158334 0.933837890625 0.001583342 0.95703125 0.00158854 0.95703125 0.001588542 0.982666015625 0.00159376 0.982666015625 0.001593762 1.009521484375 0.00159896 1.009521484375 0.001598962 1.03759765625 0.00160416 1.03759765625 0.001604162 1.068115234375 0.00160938 1.068115234375 0.001609382 1.099853515625 0.00161458 1.099853515625 0.001614582 1.134033203125 0.0016198 1.134033203125 0.001619802 1.16943359375 0.001625 1.16943359375 0.001625002 1.207275390625 0.0016302 1.207275390625 0.001630202 1.246337890625 0.00163542 1.246337890625 0.001635422 1.28662109375 0.00164062 1.28662109375 0.001640622 1.328125 0.00164584 1.328125 0.001645842 1.3720703125 0.00165104 1.3720703125 0.001651042 1.417236328125 0.00165624 1.417236328125 0.001656242 1.46484375 0.00166146 1.46484375 0.001661462 1.512451171875 0.00166666 1.512451171875 0.001666662 1.5625 0.00167188 1.5625 0.001671882 1.612548828125 0.00167708 1.612548828125 0.001677082 1.6650390625 0.0016823 1.6650390625 0.001682302 1.71875 0.0016875 1.71875 0.001687502 1.7724609375 0.0016927 1.7724609375 0.001692702 1.82861328125 0.00169792 1.82861328125 0.001697922 1.885986328125 0.00170312 1.885986328125 0.001703122 1.943359375 0.00170834 1.943359375 0.001708342 2.001953125 0.00171354 2.001953125 0.001713542 2.061767578125 0.00171876 2.061767578125 0.001718762 2.122802734375 0.00172396 2.122802734375 0.001723962 2.183837890625 0.00172916 2.183837890625 0.001729162 2.244873046875 0.00173438 2.244873046875 0.001734382 2.308349609375 0.00173958 2.308349609375 0.001739582 2.371826171875 0.0017448 2.371826171875 0.001744802 2.435302734375 0.00175 2.435302734375 0.001750002 2.498779296875 0.0017552 2.498779296875 0.001755202 2.5634765625 0.00176042 2.5634765625 0.001760422 2.62939453125 0.00176562 2.62939453125 0.001765622 2.694091796875 0.00177084 2.694091796875 0.001770842 2.760009765625 0.00177604 2.760009765625 0.001776042 2.82470703125 0.00178124 2.82470703125 0.001781242 2.890625 0.00178646 2.890625 0.001786462 2.955322265625 0.00179166 2.955322265625 0.001791662 3.021240234375 0.00179688 3.021240234375 0.001796882 3.0859375 0.00180208 3.0859375 0.001802082 3.150634765625 0.0018073 3.150634765625 0.001807302 3.21533203125 0.0018125 3.21533203125 0.001812502 3.280029296875 0.0018177 3.280029296875 0.001817702 3.343505859375 0.00182292 3.343505859375 0.001822922 3.40576171875 0.00182812 3.40576171875 0.001828122 3.468017578125 0.00183334 3.468017578125 0.001833342 3.5302734375 0.00183854 3.5302734375 0.001838542 3.59130859375 0.00184376 3.59130859375 0.001843762 3.651123046875 0.00184896 3.651123046875 0.001848962 3.7109375 0.00185416 3.7109375 0.001854162 3.768310546875 0.00185938 3.768310546875 0.001859382 3.82568359375 0.00186458 3.82568359375 0.001864582 3.8818359375 0.0018698 3.8818359375 0.001869802 3.936767578125 0.001875 3.936767578125 0.001875002 3.990478515625 0.0018802 3.990478515625 0.001880202 4.04296875 0.00188542 4.04296875 0.001885422 4.09423828125 0.00189062 4.09423828125 0.001890622 4.14306640625 0.00189584 4.14306640625 0.001895842 4.190673828125 0.00190104 4.190673828125 0.001901042 4.237060546875 0.00190624 4.237060546875 0.001906242 4.2822265625 0.00191146 4.2822265625 0.001911462 4.324951171875 0.00191666 4.324951171875 0.001916662 4.366455078125 0.00192188 4.366455078125 0.001921882 4.405517578125 0.00192708 4.405517578125 0.001927082 4.443359375 0.0019323 4.443359375 0.001932302 4.478759765625 0.0019375 4.478759765625 0.001937502 4.512939453125 0.0019427 4.512939453125 0.001942702 4.544677734375 0.00194792 4.544677734375 0.001947922 4.573974609375 0.00195312 4.573974609375 0.001953122 4.60205078125 0.00195834 4.60205078125 0.001958342 4.62646484375 0.00196354 4.62646484375 0.001963542 4.649658203125 0.00196876 4.649658203125 0.001968762 4.671630859375 0.00197396 4.671630859375 0.001973962 4.68994140625 0.00197916 4.68994140625 0.001979162 4.705810546875 0.00198438 4.705810546875 0.001984382 4.720458984375 0.00198958 4.720458984375 0.001989582 4.732666015625 0.0019948 4.732666015625 0.001994802 4.7412109375 0.002 4.7412109375 0.002000002 4.74853515625 0.0020052 4.74853515625 0.002005202 4.747314453125 0.00201042 4.747314453125 0.002010422 4.74365234375 0.00201562 4.74365234375 0.002015622 4.737548828125 0.00202084 4.737548828125 0.002020842 4.72900390625 0.00202604 4.72900390625 0.002026042 4.71923828125 0.00203124 4.71923828125 0.002031242 4.705810546875 0.00203646 4.705810546875 0.002036462 4.68994140625 0.00204166 4.68994140625 0.002041662 4.671630859375 0.00204688 4.671630859375 0.002046882 4.652099609375 0.00205208 4.652099609375 0.002052082 4.62890625 0.0020573 4.62890625 0.002057302 4.6044921875 0.0020625 4.6044921875 0.002062502 4.57763671875 0.0020677 4.57763671875 0.002067702 4.54833984375 0.00207292 4.54833984375 0.002072922 4.5166015625 0.00207812 4.5166015625 0.002078122 4.483642578125 0.00208334 4.483642578125 0.002083342 4.447021484375 0.00208854 4.447021484375 0.002088542 4.4091796875 0.00209376 4.4091796875 0.002093762 4.3701171875 0.00209896 4.3701171875 0.002098962 4.327392578125 0.00210416 4.327392578125 0.002104162 4.283447265625 0.00210938 4.283447265625 0.002109382 4.23828125 0.00211458 4.23828125 0.002114582 4.190673828125 0.0021198 4.190673828125 0.002119802 4.140625 0.002125 4.140625 0.002125002 4.090576171875 0.0021302 4.090576171875 0.002130202 4.036865234375 0.00213542 4.036865234375 0.002135422 3.98193359375 0.00214062 3.98193359375 0.002140622 3.927001953125 0.00214584 3.927001953125 0.002145842 3.868408203125 0.00215104 3.868408203125 0.002151042 3.809814453125 0.00215626 3.809814453125 0.002156262 3.748779296875 0.00216146 3.748779296875 0.002161462 3.687744140625 0.00216666 3.687744140625 0.002166662 3.624267578125 0.00217188 3.624267578125 0.002171882 3.5595703125 0.00217708 3.5595703125 0.002177082 3.494873046875 0.0021823 3.494873046875 0.002182302 3.427734375 0.0021875 3.427734375 0.002187502 3.360595703125 0.0021927 3.360595703125 0.002192702 3.292236328125 0.00219792 3.292236328125 0.002197922 3.22265625 0.00220312 3.22265625 0.002203122 3.15185546875 0.00220834 3.15185546875 0.002208342 3.0810546875 0.00221354 3.0810546875 0.002213542 3.01025390625 0.00221874 3.01025390625 0.002218742 2.938232421875 0.00222396 2.938232421875 0.002223962 2.8662109375 0.00222916 2.8662109375 0.002229162 2.79296875 0.00223438 2.79296875 0.002234382 2.7197265625 0.00223958 2.7197265625 0.002239582 2.646484375 0.0022448 2.646484375 0.002244802 2.5732421875 0.00225 2.5732421875 0.002250002 2.5 0.0022552 2.5 0.002255202 2.425537109375 0.00226042 2.425537109375 0.002260422 2.352294921875 0.00226562 2.352294921875 0.002265622 2.279052734375 0.00227084 2.279052734375 0.002270842 2.205810546875 0.00227604 2.205810546875 0.002276042 2.132568359375 0.00228124 2.132568359375 0.002281242 2.060546875 0.00228646 2.060546875 0.002286462 1.988525390625 0.00229166 1.988525390625 0.002291662 1.917724609375 0.00229688 1.917724609375 0.002296882 1.846923828125 0.00230208 1.846923828125 0.002302082 1.776123046875 0.0023073 1.776123046875 0.002307302 1.70654296875 0.0023125 1.70654296875 0.002312502 1.63818359375 0.0023177 1.63818359375 0.002317702 1.571044921875 0.00232292 1.571044921875 0.002322922 1.50390625 0.00232812 1.50390625 0.002328122 1.439208984375 0.00233334 1.439208984375 0.002333342 1.37451171875 0.00233854 1.37451171875 0.002338542 1.31103515625 0.00234376 1.31103515625 0.002343762 1.25 0.00234896 1.25 0.002348962 1.18896484375 0.00235416 1.18896484375 0.002354162 1.13037109375 0.00235938 1.13037109375 0.002359382 1.07177734375 0.00236458 1.07177734375 0.002364582 1.016845703125 0.0023698 1.016845703125 0.002369802 0.9619140625 0.002375 0.9619140625 0.002375002 0.908203125 0.0023802 0.908203125 0.002380202 0.858154296875 0.00238542 0.858154296875 0.002385422 0.80810546875 0.00239062 0.80810546875 0.002390622 0.760498046875 0.00239584 0.760498046875 0.002395842 0.71533203125 0.00240104 0.71533203125 0.002401042 0.67138671875 0.00240624 0.67138671875 0.002406242 0.628662109375 0.00241146 0.628662109375 0.002411462 0.589599609375 0.00241666 0.589599609375 0.002416662 0.5517578125 0.00242188 0.5517578125 0.002421882 0.51513671875 0.00242708 0.51513671875 0.002427082 0.482177734375 0.0024323 0.482177734375 0.002432302 0.450439453125 0.0024375 0.450439453125 0.002437502 0.421142578125 0.0024427 0.421142578125 0.002442702 0.394287109375 0.00244792 0.394287109375 0.002447922 0.369873046875 0.00245312 0.369873046875 0.002453122 0.3466796875 0.00245834 0.3466796875 0.002458342 0.3271484375 0.00246354 0.3271484375 0.002463542 0.308837890625 0.00246876 0.308837890625 0.002468762 0.29296875 0.00247396 0.29296875 0.002473962 0.279541015625 0.00247916 0.279541015625 0.002479162 0.269775390625 0.00248438 0.269775390625 0.002484382 0.26123046875 0.00248958 0.26123046875 0.002489582 0.255126953125 0.0024948 0.255126953125 0.002494802 0.25146484375 0.0025 0.25146484375 0.002500002 0.250244140625 0.0025052 0.250244140625 0.002505202 0.25146484375 0.00251042 0.25146484375 0.002510422 0.255126953125 0.00251562 0.255126953125 0.002515622 0.26123046875 0.00252084 0.26123046875 0.002520842 0.269775390625 0.00252604 0.269775390625 0.002526042 0.279541015625 0.00253124 0.279541015625 0.002531242 0.29296875 0.00253646 0.29296875 0.002536462 0.308837890625 0.00254166 0.308837890625 0.002541662 0.3271484375 0.00254688 0.3271484375 0.002546882 0.3466796875 0.00255208 0.3466796875 0.002552082 0.369873046875 0.0025573 0.369873046875 0.002557302 0.394287109375 0.0025625 0.394287109375 0.002562502 0.421142578125 0.0025677 0.421142578125 0.002567702 0.450439453125 0.00257292 0.450439453125 0.002572922 0.482177734375 0.00257812 0.482177734375 0.002578122 0.51513671875 0.00258334 0.51513671875 0.002583342 0.5517578125 0.00258854 0.5517578125 0.002588542 0.589599609375 0.00259376 0.589599609375 0.002593762 0.628662109375 0.00259896 0.628662109375 0.002598962 0.67138671875 0.00260416 0.67138671875 0.002604162 0.71533203125 0.00260938 0.71533203125 0.002609382 0.760498046875 0.00261458 0.760498046875 0.002614582 0.80810546875 0.0026198 0.80810546875 0.002619802 0.858154296875 0.002625 0.858154296875 0.002625002 0.908203125 0.0026302 0.908203125 0.002630202 0.9619140625 0.00263542 0.9619140625 0.002635422 1.016845703125 0.00264062 1.016845703125 0.002640622 1.07177734375 0.00264584 1.07177734375 0.002645842 1.13037109375 0.00265104 1.13037109375 0.002651042 1.18896484375 0.00265624 1.18896484375 0.002656242 1.25 0.00266146 1.25 0.002661462 1.31103515625 0.00266666 1.31103515625 0.002666662 1.37451171875 0.00267188 1.37451171875 0.002671882 1.439208984375 0.00267708 1.439208984375 0.002677082 1.50390625 0.0026823 1.50390625 0.002682302 1.571044921875 0.0026875 1.571044921875 0.002687502 1.63818359375 0.0026927 1.63818359375 0.002692702 1.70654296875 0.00269792 1.70654296875 0.002697922 1.776123046875 0.00270312 1.776123046875 0.002703122 1.846923828125 0.00270834 1.846923828125 0.002708342 1.917724609375 0.00271354 1.917724609375 0.002713542 1.988525390625 0.00271876 1.988525390625 0.002718762 2.060546875 0.00272396 2.060546875 0.002723962 2.132568359375 0.00272916 2.132568359375 0.002729162 2.205810546875 0.00273438 2.205810546875 0.002734382 2.279052734375 0.00273958 2.279052734375 0.002739582 2.352294921875 0.0027448 2.352294921875 0.002744802 2.425537109375 0.00275 2.425537109375 0.002750002 2.498779296875 0.0027552 2.498779296875 0.002755202 2.5732421875 0.00276042 2.5732421875 0.002760422 2.646484375 0.00276562 2.646484375 0.002765622 2.7197265625 0.00277084 2.7197265625 0.002770842 2.79296875 0.00277604 2.79296875 0.002776042 2.8662109375 0.00278124 2.8662109375 0.002781242 2.938232421875 0.00278646 2.938232421875 0.002786462 3.01025390625 0.00279166 3.01025390625 0.002791662 3.0810546875 0.00279688 3.0810546875 0.002796882 3.15185546875 0.00280208 3.15185546875 0.002802082 3.22265625 0.0028073 3.22265625 0.002807302 3.292236328125 0.0028125 3.292236328125 0.002812502 3.360595703125 0.0028177 3.360595703125 0.002817702 3.427734375 0.00282292 3.427734375 0.002822922 3.494873046875 0.00282812 3.494873046875 0.002828122 3.5595703125 0.00283334 3.5595703125 0.002833342 3.624267578125 0.00283854 3.624267578125 0.002838542 3.687744140625 0.00284376 3.687744140625 0.002843762 3.748779296875 0.00284896 3.748779296875 0.002848962 3.809814453125 0.00285416 3.809814453125 0.002854162 3.868408203125 0.00285938 3.868408203125 0.002859382 3.927001953125 0.00286458 3.927001953125 0.002864582 3.98193359375 0.0028698 3.98193359375 0.002869802 4.036865234375 0.002875 4.036865234375 0.002875002 4.090576171875 0.0028802 4.090576171875 0.002880202 4.140625 0.00288542 4.140625 0.002885422 4.190673828125 0.00289062 4.190673828125 0.002890622 4.23828125 0.00289584 4.23828125 0.002895842 4.283447265625 0.00290104 4.283447265625 0.002901042 4.327392578125 0.00290624 4.327392578125 0.002906242 4.3701171875 0.00291146 4.3701171875 0.002911462 4.4091796875 0.00291666 4.4091796875 0.002916662 4.447021484375 0.00292188 4.447021484375 0.002921882 4.483642578125 0.00292708 4.483642578125 0.002927082 4.5166015625 0.0029323 4.5166015625 0.002932302 4.54833984375 0.0029375 4.54833984375 0.002937502 4.57763671875 0.0029427 4.57763671875 0.002942702 4.6044921875 0.00294792 4.6044921875 0.002947922 4.62890625 0.00295312 4.62890625 0.002953122 4.652099609375 0.00295834 4.652099609375 0.002958342 4.671630859375 0.00296354 4.671630859375 0.002963542 4.68994140625 0.00296876 4.68994140625 0.002968762 4.705810546875 0.00297396 4.705810546875 0.002973962 4.71923828125 0.00297916 4.71923828125 0.002979162 4.72900390625 0.00298438 4.72900390625 0.002984382 4.737548828125 0.00298958 4.737548828125 0.002989582 4.74365234375 0.0029948 4.74365234375 0.002994802 4.747314453125 0.003 4.747314453125 0.003000002 4.74853515625 0.0030052 4.74853515625 0.003005202 4.747314453125 0.00301042 4.747314453125 0.003010422 4.74365234375 0.00301562 4.74365234375 0.003015622 4.737548828125 0.00302084 4.737548828125 0.003020842 4.72900390625 0.00302604 4.72900390625 0.003026042 4.71923828125 0.00303124 4.71923828125 0.003031242 4.705810546875 0.00303646 4.705810546875 0.003036462 4.68994140625 0.00304166 4.68994140625 0.003041662 4.671630859375 0.00304688 4.671630859375 0.003046882 4.652099609375 0.00305208 4.652099609375 0.003052082 4.62890625 0.0030573 4.62890625 0.003057302 4.6044921875 0.0030625 4.6044921875 0.003062502 4.57763671875 0.0030677 4.57763671875 0.003067702 4.54833984375 0.00307292 4.54833984375 0.003072922 4.5166015625 0.00307812 4.5166015625 0.003078122 4.483642578125 0.00308334 4.483642578125 0.003083342 4.447021484375 0.00308854 4.447021484375 0.003088542 4.4091796875 0.00309376 4.4091796875 0.003093762 4.3701171875 0.00309896 4.3701171875 0.003098962 4.327392578125 0.00310416 4.327392578125 0.003104162 4.283447265625 0.00310938 4.283447265625 0.003109382 4.23828125 0.00311458 4.23828125 0.003114582 4.190673828125 0.0031198 4.190673828125 0.003119802 4.140625 0.003125 4.140625 0.003125002 4.090576171875 0.0031302 4.090576171875 0.003130202 4.036865234375 0.00313542 4.036865234375 0.003135422 3.98193359375 0.00314062 3.98193359375 0.003140622 3.927001953125 0.00314584 3.927001953125 0.003145842 3.868408203125 0.00315104 3.868408203125 0.003151042 3.809814453125 0.00315624 3.809814453125 0.003156242 3.748779296875 0.00316146 3.748779296875 0.003161462 3.687744140625 0.00316666 3.687744140625 0.003166662 3.624267578125 0.00317188 3.624267578125 0.003171882 3.5595703125 0.00317708 3.5595703125 0.003177082 3.494873046875 0.0031823 3.494873046875 0.003182302 3.427734375 0.0031875 3.427734375 0.003187502 3.360595703125 0.0031927 3.360595703125 0.003192702 3.292236328125 0.00319792 3.292236328125 0.003197922 3.22265625 0.00320312 3.22265625 0.003203122 3.15185546875 0.00320834 3.15185546875 0.003208342 3.0810546875 0.00321354 3.0810546875 0.003213542 3.01025390625 0.00321876 3.01025390625 0.003218762 2.938232421875 0.00322396 2.938232421875 0.003223962 2.8662109375 0.00322916 2.8662109375 0.003229162 2.79296875 0.00323438 2.79296875 0.003234382 2.7197265625 0.00323958 2.7197265625 0.003239582 2.646484375 0.0032448 2.646484375 0.003244802 2.5732421875 0.00325 2.5732421875 0.003250002 2.5 0.0032552 2.5 0.003255202 2.425537109375 0.00326042 2.425537109375 0.003260422 2.352294921875 0.00326562 2.352294921875 0.003265622 2.279052734375 0.00327084 2.279052734375 0.003270842 2.205810546875 0.00327604 2.205810546875 0.003276042 2.132568359375 0.00328124 2.132568359375 0.003281242 2.060546875 0.00328646 2.060546875 0.003286462 1.988525390625 0.00329166 1.988525390625 0.003291662 1.917724609375 0.00329688 1.917724609375 0.003296882 1.846923828125 0.00330208 1.846923828125 0.003302082 1.776123046875 0.0033073 1.776123046875 0.003307302 1.70654296875 0.0033125 1.70654296875 0.003312502 1.63818359375 0.0033177 1.63818359375 0.003317702 1.571044921875 0.00332292 1.571044921875 0.003322922 1.50390625 0.00332812 1.50390625 0.003328122 1.439208984375 0.00333334 1.439208984375 0.003333342 1.37451171875 0.00333854 1.37451171875 0.003338542 1.31103515625 0.00334376 1.31103515625 0.003343762 1.25 0.00334896 1.25 0.003348962 1.18896484375 0.00335416 1.18896484375 0.003354162 1.13037109375 0.00335938 1.13037109375 0.003359382 1.07177734375 0.00336458 1.07177734375 0.003364582 1.016845703125 0.0033698 1.016845703125 0.003369802 0.9619140625 0.003375 0.9619140625 0.003375002 0.908203125 0.0033802 0.908203125 0.003380202 0.858154296875 0.00338542 0.858154296875 0.003385422 0.80810546875 0.00339062 0.80810546875 0.003390622 0.760498046875 0.00339584 0.760498046875 0.003395842 0.71533203125 0.00340104 0.71533203125 0.003401042 0.67138671875 0.00340624 0.67138671875 0.003406242 0.628662109375 0.00341146 0.628662109375 0.003411462 0.589599609375 0.00341666 0.589599609375 0.003416662 0.5517578125 0.00342188 0.5517578125 0.003421882 0.51513671875 0.00342708 0.51513671875 0.003427082 0.482177734375 0.0034323 0.482177734375 0.003432302 0.450439453125 0.0034375 0.450439453125 0.003437502 0.421142578125 0.0034427 0.421142578125 0.003442702 0.394287109375 0.00344792 0.394287109375 0.003447922 0.369873046875 0.00345312 0.369873046875 0.003453122 0.3466796875 0.00345834 0.3466796875 0.003458342 0.3271484375 0.00346354 0.3271484375 0.003463542 0.308837890625 0.00346876 0.308837890625 0.003468762 0.29296875 0.00347396 0.29296875 0.003473962 0.279541015625 0.00347916 0.279541015625 0.003479162 0.269775390625 0.00348438 0.269775390625 0.003484382 0.26123046875 0.00348958 0.26123046875 0.003489582 0.255126953125 0.0034948 0.255126953125 0.003494802 0.25146484375 0.0035 0.25146484375 0.003500002 0.250244140625 0.0035052 0.250244140625 0.003505202 0.25146484375 0.00351042 0.25146484375 0.003510422 0.255126953125 0.00351562 0.255126953125 0.003515622 0.26123046875 0.00352084 0.26123046875 0.003520842 0.269775390625 0.00352604 0.269775390625 0.003526042 0.279541015625 0.00353124 0.279541015625 0.003531242 0.29296875 0.00353646 0.29296875 0.003536462 0.308837890625 0.00354166 0.308837890625 0.003541662 0.3271484375 0.00354688 0.3271484375 0.003546882 0.3466796875 0.00355208 0.3466796875 0.003552082 0.369873046875 0.0035573 0.369873046875 0.003557302 0.394287109375 0.0035625 0.394287109375 0.003562502 0.421142578125 0.0035677 0.421142578125 0.003567702 0.450439453125 0.00357292 0.450439453125 0.003572922 0.482177734375 0.00357812 0.482177734375 0.003578122 0.51513671875 0.00358334 0.51513671875 0.003583342 0.5517578125 0.00358854 0.5517578125 0.003588542 0.589599609375 0.00359376 0.589599609375 0.003593762 0.628662109375 0.00359896 0.628662109375 0.003598962 0.67138671875 0.00360416 0.67138671875 0.003604162 0.71533203125 0.00360938 0.71533203125 0.003609382 0.760498046875 0.00361458 0.760498046875 0.003614582 0.80810546875 0.0036198 0.80810546875 0.003619802 0.858154296875 0.003625 0.858154296875 0.003625002 0.908203125 0.0036302 0.908203125 0.003630202 0.9619140625 0.00363542 0.9619140625 0.003635422 1.016845703125 0.00364062 1.016845703125 0.003640622 1.07177734375 0.00364584 1.07177734375 0.003645842 1.13037109375 0.00365104 1.13037109375 0.003651042 1.18896484375 0.00365624 1.18896484375 0.003656242 1.25 0.00366146 1.25 0.003661462 1.31103515625 0.00366666 1.31103515625 0.003666662 1.37451171875 0.00367188 1.37451171875 0.003671882 1.439208984375 0.00367708 1.439208984375 0.003677082 1.50390625 0.0036823 1.50390625 0.003682302 1.571044921875 0.0036875 1.571044921875 0.003687502 1.63818359375 0.0036927 1.63818359375 0.003692702 1.70654296875 0.00369792 1.70654296875 0.003697922 1.776123046875 0.00370312 1.776123046875 0.003703122 1.846923828125 0.00370834 1.846923828125 0.003708342 1.917724609375 0.00371354 1.917724609375 0.003713542 1.988525390625 0.00371876 1.988525390625 0.003718762 2.060546875 0.00372396 2.060546875 0.003723962 2.132568359375 0.00372916 2.132568359375 0.003729162 2.205810546875 0.00373438 2.205810546875 0.003734382 2.279052734375 0.00373958 2.279052734375 0.003739582 2.352294921875 0.0037448 2.352294921875 0.003744802 2.425537109375 0.00375 2.425537109375 0.003750002 2.498779296875 0.0037552 2.498779296875 0.003755202 2.5732421875 0.00376042 2.5732421875 0.003760422 2.646484375 0.00376562 2.646484375 0.003765622 2.7197265625 0.00377084 2.7197265625 0.003770842 2.79296875 0.00377604 2.79296875 0.003776042 2.8662109375 0.00378124 2.8662109375 0.003781242 2.938232421875 0.00378646 2.938232421875 0.003786462 3.01025390625 0.00379166 3.01025390625 0.003791662 3.0810546875 0.00379688 3.0810546875 0.003796882 3.15185546875 0.00380208 3.15185546875 0.003802082 3.22265625 0.0038073 3.22265625 0.003807302 3.292236328125 0.0038125 3.292236328125 0.003812502 3.360595703125 0.0038177 3.360595703125 0.003817702 3.427734375 0.00382292 3.427734375 0.003822922 3.494873046875 0.00382812 3.494873046875 0.003828122 3.5595703125 0.00383334 3.5595703125 0.003833342 3.624267578125 0.00383854 3.624267578125 0.003838542 3.687744140625 0.00384376 3.687744140625 0.003843762 3.748779296875 0.00384896 3.748779296875 0.003848962 3.809814453125 0.00385416 3.809814453125 0.003854162 3.868408203125 0.00385938 3.868408203125 0.003859382 3.927001953125 0.00386458 3.927001953125 0.003864582 3.98193359375 0.0038698 3.98193359375 0.003869802 4.036865234375 0.003875 4.036865234375 0.003875002 4.090576171875 0.0038802 4.090576171875 0.003880202 4.140625 0.00388542 4.140625 0.003885422 4.190673828125 0.00389062 4.190673828125 0.003890622 4.23828125 0.00389584 4.23828125 0.003895842 4.283447265625 0.00390104 4.283447265625 0.003901042 4.327392578125 0.00390624 4.327392578125 0.003906242 4.3701171875 0.00391146 4.3701171875 0.003911462 4.4091796875 0.00391666 4.4091796875 0.003916662 4.447021484375 0.00392188 4.447021484375 0.003921882 4.483642578125 0.00392708 4.483642578125 0.003927082 4.5166015625 0.0039323 4.5166015625 0.003932302 4.54833984375 0.0039375 4.54833984375 0.003937502 4.57763671875 0.0039427 4.57763671875 0.003942702 4.6044921875 0.00394792 4.6044921875 0.003947922 4.62890625 0.00395312 4.62890625 0.003953122 4.652099609375 0.00395834 4.652099609375 0.003958342 4.671630859375 0.00396354 4.671630859375 0.003963542 4.68994140625 0.00396876 4.68994140625 0.003968762 4.705810546875 0.00397396 4.705810546875 0.003973962 4.71923828125 0.00397916 4.71923828125 0.003979162 4.72900390625 0.00398438 4.72900390625 0.003984382 4.737548828125 0.00398958 4.737548828125 0.003989582 4.74365234375 0.0039948 4.74365234375 0.003994802 4.747314453125 0.004 4.747314453125 0.004000002 4.74853515625 0.0040052 4.74853515625 0.004005202 4.7412109375 0.00401042 4.7412109375 0.004010422 4.732666015625 0.00401562 4.732666015625 0.004015622 4.720458984375 0.00402084 4.720458984375 0.004020842 4.705810546875 0.00402604 4.705810546875 0.004026042 4.68994140625 0.00403124 4.68994140625 0.004031242 4.671630859375 0.00403646 4.671630859375 0.004036462 4.649658203125 0.00404166 4.649658203125 0.004041662 4.62646484375 0.00404688 4.62646484375 0.004046882 4.60205078125 0.00405208 4.60205078125 0.004052082 4.573974609375 0.0040573 4.573974609375 0.004057302 4.544677734375 0.0040625 4.544677734375 0.004062502 4.512939453125 0.0040677 4.512939453125 0.004067702 4.478759765625 0.00407292 4.478759765625 0.004072922 4.443359375 0.00407812 4.443359375 0.004078122 4.405517578125 0.00408334 4.405517578125 0.004083342 4.366455078125 0.00408854 4.366455078125 0.004088542 4.324951171875 0.00409376 4.324951171875 0.004093762 4.2822265625 0.00409896 4.2822265625 0.004098962 4.237060546875 0.00410416 4.237060546875 0.004104162 4.190673828125 0.00410938 4.190673828125 0.004109382 4.14306640625 0.00411458 4.14306640625 0.004114582 4.09423828125 0.0041198 4.09423828125 0.004119802 4.04296875 0.004125 4.04296875 0.004125002 3.990478515625 0.0041302 3.990478515625 0.004130202 3.936767578125 0.00413542 3.936767578125 0.004135422 3.8818359375 0.00414062 3.8818359375 0.004140622 3.82568359375 0.00414584 3.82568359375 0.004145842 3.768310546875 0.00415104 3.768310546875 0.004151042 3.7109375 0.00415624 3.7109375 0.004156242 3.651123046875 0.00416146 3.651123046875 0.004161462 3.59130859375 0.00416666 3.59130859375 0.004166662 3.5302734375 0.00417188 3.5302734375 0.004171882 3.468017578125 0.00417708 3.468017578125 0.004177082 3.40576171875 0.0041823 3.40576171875 0.004182302 3.343505859375 0.0041875 3.343505859375 0.004187502 3.280029296875 0.0041927 3.280029296875 0.004192702 3.21533203125 0.00419792 3.21533203125 0.004197922 3.150634765625 0.00420312 3.150634765625 0.004203122 3.0859375 0.00420834 3.0859375 0.004208342 3.021240234375 0.00421354 3.021240234375 0.004213542 2.955322265625 0.00421876 2.955322265625 0.004218762 2.890625 0.00422396 2.890625 0.004223962 2.82470703125 0.00422916 2.82470703125 0.004229162 2.760009765625 0.00423438 2.760009765625 0.004234382 2.694091796875 0.00423958 2.694091796875 0.004239582 2.62939453125 0.0042448 2.62939453125 0.004244802 2.5634765625 0.00425 2.5634765625 0.004250002 2.498779296875 0.0042552 2.498779296875 0.004255202 2.435302734375 0.00426042 2.435302734375 0.004260422 2.371826171875 0.00426562 2.371826171875 0.004265622 2.308349609375 0.00427084 2.308349609375 0.004270842 2.244873046875 0.00427604 2.244873046875 0.004276042 2.183837890625 0.00428126 2.183837890625 0.004281262 2.12158203125 0.00428646 2.12158203125 0.004286462 2.061767578125 0.00429166 2.061767578125 0.004291662 2.001953125 0.00429688 2.001953125 0.004296882 1.943359375 0.00430208 1.943359375 0.004302082 1.885986328125 0.0043073 1.885986328125 0.004307302 1.82861328125 0.0043125 1.82861328125 0.004312502 1.7724609375 0.0043177 1.7724609375 0.004317702 1.71875 0.00432292 1.71875 0.004322922 1.6650390625 0.00432812 1.6650390625 0.004328122 1.612548828125 0.00433334 1.612548828125 0.004333342 1.5625 0.00433854 1.5625 0.004338542 1.512451171875 0.00434376 1.512451171875 0.004343762 1.46484375 0.00434896 1.46484375 0.004348962 1.417236328125 0.00435416 1.417236328125 0.004354162 1.3720703125 0.00435938 1.3720703125 0.004359382 1.328125 0.00436458 1.328125 0.004364582 1.28662109375 0.0043698 1.28662109375 0.004369802 1.246337890625 0.004375 1.246337890625 0.004375002 1.207275390625 0.0043802 1.207275390625 0.004380202 1.16943359375 0.00438542 1.16943359375 0.004385422 1.134033203125 0.00439062 1.134033203125 0.004390622 1.099853515625 0.00439584 1.099853515625 0.004395842 1.068115234375 0.00440104 1.068115234375 0.004401042 1.03759765625 0.00440624 1.03759765625 0.004406242 1.009521484375 0.00441146 1.009521484375 0.004411462 0.982666015625 0.00441666 0.982666015625 0.004416662 0.95703125 0.00442188 0.95703125 0.004421882 0.933837890625 0.00442708 0.933837890625 0.004427082 0.9130859375 0.0044323 0.9130859375 0.004432302 0.8935546875 0.0044375 0.8935546875 0.004437502 0.875244140625 0.0044427 0.875244140625 0.004442702 0.860595703125 0.00444792 0.860595703125 0.004447922 0.845947265625 0.00445312 0.845947265625 0.004453122 0.8349609375 0.00445834 0.8349609375 0.004458342 0.823974609375 0.00446354 0.823974609375 0.004463542 0.816650390625 0.00446874 0.816650390625 0.004468742 0.810546875 0.00447396 0.810546875 0.004473962 0.8056640625 0.00447916 0.8056640625 0.004479162 0.80322265625 0.00448958 0.80322265625 0.004489582 0.804443359375 0.0044948 0.804443359375 0.004494802 0.806884765625 0.0045 0.806884765625 0.004500002 0.811767578125 0.0045052 0.811767578125 0.004505202 0.819091796875 0.00451042 0.819091796875 0.004510422 0.82763671875 0.00451562 0.82763671875 0.004515622 0.83740234375 0.00452084 0.83740234375 0.004520842 0.849609375 0.00452604 0.849609375 0.004526042 0.8642578125 0.00453124 0.8642578125 0.004531242 0.87890625 0.00453646 0.87890625 0.004536462 0.89599609375 0.00454166 0.89599609375 0.004541662 0.91552734375 0.00454688 0.91552734375 0.004546882 0.93505859375 0.00455208 0.93505859375 0.004552082 0.95703125 0.0045573 0.95703125 0.004557302 0.980224609375 0.0045625 0.980224609375 0.004562502 1.005859375 0.0045677 1.005859375 0.004567702 1.031494140625 0.00457292 1.031494140625 0.004572922 1.0595703125 0.00457812 1.0595703125 0.004578122 1.0888671875 0.00458334 1.0888671875 0.004583342 1.119384765625 0.00458854 1.119384765625 0.004588542 1.151123046875 0.00459376 1.151123046875 0.004593762 1.18408203125 0.00459896 1.18408203125 0.004598962 1.21826171875 0.00460416 1.21826171875 0.004604162 1.253662109375 0.00460938 1.253662109375 0.004609382 1.290283203125 0.00461458 1.290283203125 0.004614582 1.328125 0.0046198 1.328125 0.004619802 1.365966796875 0.004625 1.365966796875 0.004625002 1.40625 0.0046302 1.40625 0.004630202 1.446533203125 0.00463542 1.446533203125 0.004635422 1.488037109375 0.00464062 1.488037109375 0.004640622 1.529541015625 0.00464584 1.529541015625 0.004645842 1.572265625 0.00465104 1.572265625 0.004651042 1.6162109375 0.00465624 1.6162109375 0.004656242 1.66015625 0.00466146 1.66015625 0.004661462 1.7041015625 0.00466666 1.7041015625 0.004666662 1.749267578125 0.00467188 1.749267578125 0.004671882 1.795654296875 0.00467708 1.795654296875 0.004677082 1.8408203125 0.0046823 1.8408203125 0.004682302 1.88720703125 0.0046875 1.88720703125 0.004687502 1.934814453125 0.0046927 1.934814453125 0.004692702 1.981201171875 0.00469792 1.981201171875 0.004697922 2.02880859375 0.00470312 2.02880859375 0.004703122 2.076416015625 0.00470834 2.076416015625 0.004708342 2.1240234375 0.00471354 2.1240234375 0.004713542 2.17041015625 0.00471876 2.17041015625 0.004718762 2.218017578125 0.00472396 2.218017578125 0.004723962 2.265625 0.00472916 2.265625 0.004729162 2.313232421875 0.00473438 2.313232421875 0.004734382 2.359619140625 0.00473958 2.359619140625 0.004739582 2.4072265625 0.0047448 2.4072265625 0.004744802 2.45361328125 0.00475 2.45361328125 0.004750002 2.498779296875 0.0047552 2.498779296875 0.004755202 2.545166015625 0.00476042 2.545166015625 0.004760422 2.59033203125 0.00476562 2.59033203125 0.004765622 2.635498046875 0.00477084 2.635498046875 0.004770842 2.679443359375 0.00477604 2.679443359375 0.004776042 2.723388671875 0.00478124 2.723388671875 0.004781242 2.767333984375 0.00478646 2.767333984375 0.004786462 2.808837890625 0.00479166 2.808837890625 0.004791662 2.8515625 0.00479688 2.8515625 0.004796882 2.891845703125 0.00480208 2.891845703125 0.004802082 2.93212890625 0.0048073 2.93212890625 0.004807302 2.972412109375 0.0048125 2.972412109375 0.004812502 3.01025390625 0.0048177 3.01025390625 0.004817702 3.048095703125 0.00482292 3.048095703125 0.004822922 3.084716796875 0.00482812 3.084716796875 0.004828122 3.1201171875 0.00483334 3.1201171875 0.004833342 3.155517578125 0.00483854 3.155517578125 0.004838542 3.189697265625 0.00484376 3.189697265625 0.004843762 3.221435546875 0.00484896 3.221435546875 0.004848962 3.253173828125 0.00485416 3.253173828125 0.004854162 3.28369140625 0.00485938 3.28369140625 0.004859382 3.31298828125 0.00486458 3.31298828125 0.004864582 3.341064453125 0.0048698 3.341064453125 0.004869802 3.367919921875 0.004875 3.367919921875 0.004875002 3.3935546875 0.0048802 3.3935546875 0.004880202 3.419189453125 0.00488542 3.419189453125 0.004885422 3.4423828125 0.00489062 3.4423828125 0.004890622 3.46435546875 0.00489584 3.46435546875 0.004895842 3.485107421875 0.00490104 3.485107421875 0.004901042 3.504638671875 0.00490624 3.504638671875 0.004906242 3.521728515625 0.00491146 3.521728515625 0.004911462 3.538818359375 0.00491666 3.538818359375 0.004916662 3.5546875 0.00492188 3.5546875 0.004921882 3.5693359375 0.00492708 3.5693359375 0.004927082 3.58154296875 0.0049323 3.58154296875 0.004932302 3.59375 0.0049375 3.59375 0.004937502 3.603515625 0.0049427 3.603515625 0.004942702 3.612060546875 0.00494792 3.612060546875 0.004947922 3.619384765625 0.00495312 3.619384765625 0.004953122 3.626708984375 0.00495834 3.626708984375 0.004958342 3.631591796875 0.00496354 3.631591796875 0.004963542 3.63525390625 0.00496876 3.63525390625 0.004968762 3.636474609375 0.00497396 3.636474609375 0.004973962 3.6376953125 0.00498438 3.6376953125 0.004984382 3.636474609375 0.00498958 3.636474609375 0.004989582 3.6328125 0.0049948 3.6328125 0.004994802 3.629150390625 0.005 3.629150390625 0.005000002 3.624267578125 0.0050052 3.624267578125 0.005005202 3.6181640625 0.00501042 3.6181640625 0.005010422 3.609619140625 0.00501562 3.609619140625 0.005015622 3.60107421875 0.00502084 3.60107421875 0.005020842 3.59130859375 0.00502604 3.59130859375 0.005026042 3.580322265625 0.00503124 3.580322265625 0.005031242 3.568115234375 0.00503646 3.568115234375 0.005036462 3.5546875 0.00504166 3.5546875 0.005041662 3.5400390625 0.00504688 3.5400390625 0.005046882 3.525390625 0.00505208 3.525390625 0.005052082 3.509521484375 0.0050573 3.509521484375 0.005057302 3.4912109375 0.0050625 3.4912109375 0.005062502 3.47412109375 0.0050677 3.47412109375 0.005067702 3.45458984375 0.00507292 3.45458984375 0.005072922 3.43505859375 0.00507812 3.43505859375 0.005078122 3.414306640625 0.00508334 3.414306640625 0.005083342 3.392333984375 0.00508854 3.392333984375 0.005088542 3.370361328125 0.00509376 3.370361328125 0.005093762 3.34716796875 0.00509896 3.34716796875 0.005098962 3.32275390625 0.00510416 3.32275390625 0.005104162 3.29833984375 0.00510938 3.29833984375 0.005109382 3.27392578125 0.00511458 3.27392578125 0.005114582 3.248291015625 0.0051198 3.248291015625 0.005119802 3.221435546875 0.005125 3.221435546875 0.005125002 3.19580078125 0.0051302 3.19580078125 0.005130202 3.167724609375 0.00513542 3.167724609375 0.005135422 3.140869140625 0.00514062 3.140869140625 0.005140622 3.11279296875 0.00514584 3.11279296875 0.005145842 3.084716796875 0.00515104 3.084716796875 0.005151042 3.055419921875 0.00515624 3.055419921875 0.005156242 3.026123046875 0.00516146 3.026123046875 0.005161462 2.996826171875 0.00516666 2.996826171875 0.005166662 2.967529296875 0.00517188 2.967529296875 0.005171882 2.938232421875 0.00517708 2.938232421875 0.005177082 2.908935546875 0.0051823 2.908935546875 0.005182302 2.87841796875 0.0051875 2.87841796875 0.005187502 2.84912109375 0.0051927 2.84912109375 0.005192702 2.81982421875 0.00519792 2.81982421875 0.005197922 2.789306640625 0.00520312 2.789306640625 0.005203122 2.760009765625 0.00520834 2.760009765625 0.005208342 2.7294921875 0.00521354 2.7294921875 0.005213542 2.7001953125 0.00521876 2.7001953125 0.005218762 2.6708984375 0.00522396 2.6708984375 0.005223962 2.6416015625 0.00522916 2.6416015625 0.005229162 2.6123046875 0.00523438 2.6123046875 0.005234382 2.584228515625 0.00523958 2.584228515625 0.005239582 2.554931640625 0.0052448 2.554931640625 0.005244802 2.52685546875 0.00525 2.52685546875 0.005250002 2.498779296875 0.0052552 2.498779296875 0.005255202 2.471923828125 0.00526042 2.471923828125 0.005260422 2.445068359375 0.00526562 2.445068359375 0.005265622 2.418212890625 0.00527084 2.418212890625 0.005270842 2.392578125 0.00527604 2.392578125 0.005276042 2.366943359375 0.00528124 2.366943359375 0.005281242 2.34130859375 0.00528646 2.34130859375 0.005286462 2.31689453125 0.00529166 2.31689453125 0.005291662 2.293701171875 0.00529688 2.293701171875 0.005296882 2.269287109375 0.00530208 2.269287109375 0.005302082 2.247314453125 0.0053073 2.247314453125 0.005307302 2.225341796875 0.0053125 2.225341796875 0.005312502 2.203369140625 0.0053177 2.203369140625 0.005317702 2.1826171875 0.00532292 2.1826171875 0.005322922 2.1630859375 0.00532812 2.1630859375 0.005328122 2.1435546875 0.00533334 2.1435546875 0.005333342 2.1240234375 0.00533854 2.1240234375 0.005338542 2.10693359375 0.00534376 2.10693359375 0.005343762 2.08984375 0.00534896 2.08984375 0.005348962 2.07275390625 0.00535416 2.07275390625 0.005354162 2.056884765625 0.00535938 2.056884765625 0.005359382 2.042236328125 0.00536458 2.042236328125 0.005364582 2.027587890625 0.0053698 2.027587890625 0.005369802 2.015380859375 0.005375 2.015380859375 0.005375002 2.001953125 0.0053802 2.001953125 0.005380202 1.990966796875 0.00538542 1.990966796875 0.005385422 1.97998046875 0.00539062 1.97998046875 0.005390622 1.968994140625 0.00539584 1.968994140625 0.005395842 1.96044921875 0.00540104 1.96044921875 0.005401042 1.951904296875 0.00540624 1.951904296875 0.005406242 1.944580078125 0.00541146 1.944580078125 0.005411462 1.937255859375 0.00541666 1.937255859375 0.005416662 1.93115234375 0.00542188 1.93115234375 0.005421882 1.92626953125 0.00542708 1.92626953125 0.005427082 1.92138671875 0.0054323 1.92138671875 0.005432302 1.917724609375 0.0054375 1.917724609375 0.005437502 1.915283203125 0.0054427 1.915283203125 0.005442702 1.912841796875 0.00544792 1.912841796875 0.005447922 1.91162109375 0.00545312 1.91162109375 0.005453122 1.910400390625 0.00546354 1.910400390625 0.005463542 1.91162109375 0.00546876 1.91162109375 0.005468762 1.912841796875 0.00547396 1.912841796875 0.005473962 1.915283203125 0.00547916 1.915283203125 0.005479162 1.9189453125 0.00548438 1.9189453125 0.005484382 1.922607421875 0.00548958 1.922607421875 0.005489582 1.92626953125 0.0054948 1.92626953125 0.005494802 1.93115234375 0.0055 1.93115234375 0.005500002 1.937255859375 0.0055052 1.937255859375 0.005505202 1.943359375 0.00551042 1.943359375 0.005510422 1.949462890625 0.00551562 1.949462890625 0.005515622 1.956787109375 0.00552084 1.956787109375 0.005520842 1.96533203125 0.00552604 1.96533203125 0.005526042 1.973876953125 0.00553124 1.973876953125 0.005531242 1.982421875 0.00553646 1.982421875 0.005536462 1.9921875 0.00554166 1.9921875 0.005541662 2.001953125 0.00554688 2.001953125 0.005546882 2.01171875 0.00555208 2.01171875 0.005552082 2.022705078125 0.0055573 2.022705078125 0.005557302 2.03369140625 0.0055625 2.03369140625 0.005562502 2.044677734375 0.0055677 2.044677734375 0.005567702 2.056884765625 0.00557292 2.056884765625 0.005572922 2.069091796875 0.00557812 2.069091796875 0.005578122 2.081298828125 0.00558334 2.081298828125 0.005583342 2.093505859375 0.00558854 2.093505859375 0.005588542 2.10693359375 0.00559376 2.10693359375 0.005593762 2.119140625 0.00559896 2.119140625 0.005598962 2.132568359375 0.00560416 2.132568359375 0.005604162 2.14599609375 0.00560938 2.14599609375 0.005609382 2.159423828125 0.00561458 2.159423828125 0.005614582 2.174072265625 0.0056198 2.174072265625 0.005619802 2.1875 0.005625 2.1875 0.005625002 2.200927734375 0.0056302 2.200927734375 0.005630202 2.215576171875 0.00563542 2.215576171875 0.005635422 2.22900390625 0.00564062 2.22900390625 0.005640622 2.242431640625 0.00564584 2.242431640625 0.005645842 2.257080078125 0.00565104 2.257080078125 0.005651042 2.2705078125 0.00565624 2.2705078125 0.005656242 2.28515625 0.00566146 2.28515625 0.005661462 2.298583984375 0.00566666 2.298583984375 0.005666662 2.31201171875 0.00567188 2.31201171875 0.005671882 2.325439453125 0.00567708 2.325439453125 0.005677082 2.3388671875 0.0056823 2.3388671875 0.005682302 2.352294921875 0.0056875 2.352294921875 0.005687502 2.364501953125 0.0056927 2.364501953125 0.005692702 2.3779296875 0.00569792 2.3779296875 0.005697922 2.39013671875 0.00570312 2.39013671875 0.005703122 2.40234375 0.00570834 2.40234375 0.005708342 2.41455078125 0.00571354 2.41455078125 0.005713542 2.4267578125 0.00571876 2.4267578125 0.005718762 2.437744140625 0.00572396 2.437744140625 0.005723962 2.44873046875 0.00572916 2.44873046875 0.005729162 2.459716796875 0.00573438 2.459716796875 0.005734382 2.470703125 0.00573958 2.470703125 0.005739582 2.48046875 0.0057448 2.48046875 0.005744802 2.490234375 0.00575 2.490234375 0.005750002 2.498779296875 0.0057552 2.498779296875 0.005755202 2.508544921875 0.00576042 2.508544921875 0.005760422 2.51708984375 0.00576562 2.51708984375 0.005765622 2.525634765625 0.00577084 2.525634765625 0.005770842 2.532958984375 0.00577604 2.532958984375 0.005776042 2.540283203125 0.00578124 2.540283203125 0.005781242 2.547607421875 0.00578646 2.547607421875 0.005786462 2.5537109375 0.00579166 2.5537109375 0.005791662 2.559814453125 0.00579688 2.559814453125 0.005796882 2.56591796875 0.00580208 2.56591796875 0.005802082 2.57080078125 0.0058073 2.57080078125 0.005807302 2.57568359375 0.0058125 2.57568359375 0.005812502 2.58056640625 0.0058177 2.58056640625 0.005817702 2.584228515625 0.00582292 2.584228515625 0.005822922 2.587890625 0.00582812 2.587890625 0.005828122 2.59033203125 0.00583334 2.59033203125 0.005833342 2.5927734375 0.00583854 2.5927734375 0.005838542 2.59521484375 0.00584376 2.59521484375 0.005843762 2.596435546875 0.00584896 2.596435546875 0.005848962 2.598876953125 0.00585938 2.598876953125 0.005859382 2.60009765625 0.005875 2.60009765625 0.005875002 2.598876953125 0.0058802 2.598876953125 0.005880202 2.59765625 0.00588542 2.59765625 0.005885422 2.596435546875 0.00589062 2.596435546875 0.005890622 2.593994140625 0.00589584 2.593994140625 0.005895842 2.5927734375 0.00590104 2.5927734375 0.005901042 2.59033203125 0.00590624 2.59033203125 0.005906242 2.586669921875 0.00591146 2.586669921875 0.005911462 2.584228515625 0.00591666 2.584228515625 0.005916662 2.58056640625 0.00592188 2.58056640625 0.005921882 2.576904296875 0.00592708 2.576904296875 0.005927082 2.5732421875 0.0059323 2.5732421875 0.005932302 2.568359375 0.0059375 2.568359375 0.005937502 2.564697265625 0.0059427 2.564697265625 0.005942702 2.559814453125 0.00594792 2.559814453125 0.005947922 2.554931640625 0.00595312 2.554931640625 0.005953122 2.550048828125 0.00595834 2.550048828125 0.005958342 2.545166015625 0.00596354 2.545166015625 0.005963542 2.5390625 0.00596876 2.5390625 0.005968762 2.5341796875 0.00597396 2.5341796875 0.005973962 2.528076171875 0.00597916 2.528076171875 0.005979162 2.523193359375 0.00598438 2.523193359375 0.005984382 2.51708984375 0.00598958 2.51708984375 0.005989582 2.510986328125 0.0059948 2.510986328125 0.005994802 2.5048828125 0.006 2.5048828125 0.006000002 2.5 0.0060052 2.5 0.006005202 2.49267578125 0.00601042 2.49267578125 0.006010422 2.486572265625 0.00601562 2.486572265625 0.006015622 2.48046875 0.00602084 2.48046875 0.006020842 2.47314453125 0.00602604 2.47314453125 0.006026042 2.467041015625 0.00603124 2.467041015625 0.006031242 2.4609375 0.00603646 2.4609375 0.006036462 2.45361328125 0.00604166 2.45361328125 0.006041662 2.447509765625 0.00604688 2.447509765625 0.006046882 2.44140625 0.00605208 2.44140625 0.006052082 2.43408203125 0.0060573 2.43408203125 0.006057302 2.427978515625 0.0060625 2.427978515625 0.006062502 2.421875 0.0060677 2.421875 0.006067702 2.41455078125 0.00607292 2.41455078125 0.006072922 2.408447265625 0.00607812 2.408447265625 0.006078122 2.40234375 0.00608334 2.40234375 0.006083342 2.39501953125 0.00608854 2.39501953125 0.006088542 2.388916015625 0.00609376 2.388916015625 0.006093762 2.3828125 0.00609896 2.3828125 0.006098962 2.37548828125 0.00610416 2.37548828125 0.006104162 2.369384765625 0.00610938 2.369384765625 0.006109382 2.36328125 0.00611458 2.36328125 0.006114582 2.35595703125 0.0061198 2.35595703125 0.006119802 2.349853515625 0.006125 2.349853515625 0.006125002 2.34375 0.0061302 2.34375 0.006130202 2.33642578125 0.00613542 2.33642578125 0.006135422 2.330322265625 0.00614062 2.330322265625 0.006140622 2.32421875 0.00614584 2.32421875 0.006145842 2.31689453125 0.00615104 2.31689453125 0.006151042 2.310791015625 0.00615624 2.310791015625 0.006156242 2.3046875 0.00616146 2.3046875 0.006161462 2.29736328125 0.00616666 2.29736328125 0.006166662 2.291259765625 0.00617188 2.291259765625 0.006171882 2.28515625 0.00617708 2.28515625 0.006177082 2.27783203125 0.0061823 2.27783203125 0.006182302 2.271728515625 0.0061875 2.271728515625 0.006187502 2.265625 0.0061927 2.265625 0.006192702 2.25830078125 0.00619792 2.25830078125 0.006197922 2.252197265625 0.00620312 2.252197265625 0.006203122 2.24609375 0.00620834 2.24609375 0.006208342 2.23876953125 0.00621354 2.23876953125 0.006213542 2.232666015625 0.00621876 2.232666015625 0.006218762 2.2265625 0.00622396 2.2265625 0.006223962 2.21923828125 0.00622916 2.21923828125 0.006229162 2.213134765625 0.00623438 2.213134765625 0.006234382 2.20703125 0.00623958 2.20703125 0.006239582 2.19970703125 0.0062448 2.19970703125 0.006244802 2.193603515625 0.00625 2.193603515625 0.006250002 2.1875 0.0062552 2.1875 0.006255202 2.18017578125 0.00626042 2.18017578125 0.006260422 2.174072265625 0.00626562 2.174072265625 0.006265622 2.16796875 0.00627084 2.16796875 0.006270842 2.16064453125 0.00627604 2.16064453125 0.006276042 2.154541015625 0.00628124 2.154541015625 0.006281242 2.1484375 0.00628646 2.1484375 0.006286462 2.14111328125 0.00629166 2.14111328125 0.006291662 2.135009765625 0.00629688 2.135009765625 0.006296882 2.12890625 0.00630208 2.12890625 0.006302082 2.12158203125 0.0063073 2.12158203125 0.006307302 2.115478515625 0.0063125 2.115478515625 0.006312502 2.109375 0.0063177 2.109375 0.006317702 2.10205078125 0.00632292 2.10205078125 0.006322922 2.095947265625 0.00632812 2.095947265625 0.006328122 2.08984375 0.00633334 2.08984375 0.006333342 2.08251953125 0.00633854 2.08251953125 0.006338542 2.076416015625 0.00634376 2.076416015625 0.006343762 2.0703125 0.00634896 2.0703125 0.006348962 2.06298828125 0.00635416 2.06298828125 0.006354162 2.056884765625 0.00635938 2.056884765625 0.006359382 2.05078125 0.00636458 2.05078125 0.006364582 2.04345703125 0.0063698 2.04345703125 0.006369802 2.037353515625 0.006375 2.037353515625 0.006375002 2.03125 0.0063802 2.03125 0.006380202 2.02392578125 0.00638542 2.02392578125 0.006385422 2.017822265625 0.00639062 2.017822265625 0.006390622 2.01171875 0.00639584 2.01171875 0.006395842 2.00439453125 0.00640104 2.00439453125 0.006401042 1.998291015625 0.00640624 1.998291015625 0.006406242 1.9921875 0.00641146 1.9921875 0.006411462 1.98486328125 0.00641666 1.98486328125 0.006416662 1.978759765625 0.00642188 1.978759765625 0.006421882 1.97265625 0.00642708 1.97265625 0.006427082 1.96533203125 0.0064323 1.96533203125 0.006432302 1.959228515625 0.0064375 1.959228515625 0.006437502 1.953125 0.0064427 1.953125 0.006442702 1.94580078125 0.00644792 1.94580078125 0.006447922 1.939697265625 0.00645312 1.939697265625 0.006453122 1.93359375 0.00645834 1.93359375 0.006458342 1.92626953125 0.00646354 1.92626953125 0.006463542 1.920166015625 0.00646876 1.920166015625 0.006468762 1.9140625 0.00647396 1.9140625 0.006473962 1.90673828125 0.00647916 1.90673828125 0.006479162 1.900634765625 0.00648438 1.900634765625 0.006484382 1.89453125 0.00648958 1.89453125 0.006489582 1.88720703125 0.0064948 1.88720703125 0.006494802 1.881103515625 0.0065 1.881103515625 0.006500002 1.875 0.0065052 1.875 0.006505202 1.86767578125 0.00651042 1.86767578125 0.006510422 1.861572265625 0.00651562 1.861572265625 0.006515622 1.85546875 0.00652084 1.85546875 0.006520842 1.84814453125 0.00652604 1.84814453125 0.006526042 1.842041015625 0.00653124 1.842041015625 0.006531242 1.8359375 0.00653646 1.8359375 0.006536462 1.82861328125 0.00654166 1.82861328125 0.006541662 1.822509765625 0.00654688 1.822509765625 0.006546882 1.81640625 0.00655208 1.81640625 0.006552082 1.80908203125 0.0065573 1.80908203125 0.006557302 1.802978515625 0.0065625 1.802978515625 0.006562502 1.796875 0.0065677 1.796875 0.006567702 1.78955078125 0.00657292 1.78955078125 0.006572922 1.783447265625 0.00657812 1.783447265625 0.006578122 1.77734375 0.00658334 1.77734375 0.006583342 1.77001953125 0.00658854 1.77001953125 0.006588542 1.763916015625 0.00659376 1.763916015625 0.006593762 1.7578125 0.00659896 1.7578125 0.006598962 1.75048828125 0.00660416 1.75048828125 0.006604162 1.744384765625 0.00660938 1.744384765625 0.006609382 1.73828125 0.00661458 1.73828125 0.006614582 1.73095703125 0.0066198 1.73095703125 0.006619802 1.724853515625 0.006625 1.724853515625 0.006625002 1.71875 0.0066302 1.71875 0.006630202 1.71142578125 0.00663542 1.71142578125 0.006635422 1.705322265625 0.00664062 1.705322265625 0.006640622 1.69921875 0.00664584 1.69921875 0.006645842 1.69189453125 0.00665104 1.69189453125 0.006651042 1.685791015625 0.00665624 1.685791015625 0.006656242 1.6796875 0.00666146 1.6796875 0.006661462 1.67236328125 0.00666666 1.67236328125 0.006666662 1.666259765625 0.00667188 1.666259765625 0.006671882 1.66015625 0.00667708 1.66015625 0.006677082 1.65283203125 0.0066823 1.65283203125 0.006682302 1.646728515625 0.0066875 1.646728515625 0.006687502 1.640625 0.0066927 1.640625 0.006692702 1.63330078125 0.00669792 1.63330078125 0.006697922 1.627197265625 0.00670312 1.627197265625 0.006703122 1.62109375 0.00670834 1.62109375 0.006708342 1.61376953125 0.00671354 1.61376953125 0.006713542 1.607666015625 0.00671876 1.607666015625 0.006718762 1.6015625 0.00672396 1.6015625 0.006723962 1.59423828125 0.00672916 1.59423828125 0.006729162 1.588134765625 0.00673438 1.588134765625 0.006734382 1.58203125 0.00673958 1.58203125 0.006739582 1.57470703125 0.0067448 1.57470703125 0.006744802 1.568603515625 0.00675 1.568603515625 0.006750002 1.5625 0.0067552 1.5625 0.006755202 1.55517578125 0.00676042 1.55517578125 0.006760422 1.549072265625 0.00676562 1.549072265625 0.006765622 1.54296875 0.00677084 1.54296875 0.006770842 1.53564453125 0.00677604 1.53564453125 0.006776042 1.529541015625 0.00678124 1.529541015625 0.006781242 1.5234375 0.00678646 1.5234375 0.006786462 1.51611328125 0.00679166 1.51611328125 0.006791662 1.510009765625 0.00679688 1.510009765625 0.006796882 1.50390625 0.00680208 1.50390625 0.006802082 1.49658203125 0.0068073 1.49658203125 0.006807302 1.490478515625 0.0068125 1.490478515625 0.006812502 1.484375 0.0068177 1.484375 0.006817702 1.47705078125 0.00682292 1.47705078125 0.006822922 1.470947265625 0.00682812 1.470947265625 0.006828122 1.46484375 0.00683334 1.46484375 0.006833342 1.45751953125 0.00683854 1.45751953125 0.006838542 1.451416015625 0.00684376 1.451416015625 0.006843762 1.4453125 0.00684896 1.4453125 0.006848962 1.43798828125 0.00685416 1.43798828125 0.006854162 1.431884765625 0.00685938 1.431884765625 0.006859382 1.42578125 0.00686458 1.42578125 0.006864582 1.41845703125 0.0068698 1.41845703125 0.006869802 1.412353515625 0.006875 1.412353515625 0.006875002 1.40625 0.0068802 1.40625 0.006880202 1.39892578125 0.00688542 1.39892578125 0.006885422 1.392822265625 0.00689062 1.392822265625 0.006890622 1.38671875 0.00689584 1.38671875 0.006895842 1.37939453125 0.00690104 1.37939453125 0.006901042 1.373291015625 0.00690624 1.373291015625 0.006906242 1.3671875 0.00691146 1.3671875 0.006911462 1.35986328125 0.00691666 1.35986328125 0.006916662 1.353759765625 0.00692188 1.353759765625 0.006921882 1.34765625 0.00692708 1.34765625 0.006927082 1.34033203125 0.0069323 1.34033203125 0.006932302 1.334228515625 0.0069375 1.334228515625 0.006937502 1.328125 0.0069427 1.328125 0.006942702 1.32080078125 0.00694792 1.32080078125 0.006947922 1.314697265625 0.00695312 1.314697265625 0.006953122 1.30859375 0.00695834 1.30859375 0.006958342 1.30126953125 0.00696354 1.30126953125 0.006963542 1.295166015625 0.00696876 1.295166015625 0.006968762 1.2890625 0.00697396 1.2890625 0.006973962 1.28173828125 0.00697916 1.28173828125 0.006979162 1.275634765625 0.00698438 1.275634765625 0.006984382 1.26953125 0.00698958 1.26953125 0.006989582 1.26220703125 0.0069948 1.26220703125 0.006994802 1.256103515625 0.007 1.256103515625 0.007000002 1.25 0.0070052 1.25 0.007005202 1.24267578125 0.00701042 1.24267578125 0.007010422 1.236572265625 0.00701562 1.236572265625 0.007015622 1.23046875 0.00702084 1.23046875 0.007020842 1.22314453125 0.00702604 1.22314453125 0.007026042 1.217041015625 0.00703124 1.217041015625 0.007031242 1.2109375 0.00703646 1.2109375 0.007036462 1.20361328125 0.00704166 1.20361328125 0.007041662 1.197509765625 0.00704688 1.197509765625 0.007046882 1.19140625 0.00705208 1.19140625 0.007052082 1.18408203125 0.0070573 1.18408203125 0.007057302 1.177978515625 0.0070625 1.177978515625 0.007062502 1.171875 0.0070677 1.171875 0.007067702 1.16455078125 0.00707292 1.16455078125 0.007072922 1.158447265625 0.00707812 1.158447265625 0.007078122 1.15234375 0.00708334 1.15234375 0.007083342 1.14501953125 0.00708854 1.14501953125 0.007088542 1.138916015625 0.00709376 1.138916015625 0.007093762 1.1328125 0.00709896 1.1328125 0.007098962 1.12548828125 0.00710416 1.12548828125 0.007104162 1.119384765625 0.00710938 1.119384765625 0.007109382 1.11328125 0.00711458 1.11328125 0.007114582 1.10595703125 0.0071198 1.10595703125 0.007119802 1.099853515625 0.007125 1.099853515625 0.007125002 1.09375 0.0071302 1.09375 0.007130202 1.08642578125 0.00713542 1.08642578125 0.007135422 1.080322265625 0.00714062 1.080322265625 0.007140622 1.07421875 0.00714584 1.07421875 0.007145842 1.06689453125 0.00715104 1.06689453125 0.007151042 1.060791015625 0.00715624 1.060791015625 0.007156242 1.0546875 0.00716146 1.0546875 0.007161462 1.04736328125 0.00716666 1.04736328125 0.007166662 1.041259765625 0.00717188 1.041259765625 0.007171882 1.03515625 0.00717708 1.03515625 0.007177082 1.02783203125 0.0071823 1.02783203125 0.007182302 1.021728515625 0.0071875 1.021728515625 0.007187502 1.015625 0.0071927 1.015625 0.007192702 1.00830078125 0.00719792 1.00830078125 0.007197922 1.002197265625 0.00720312 1.002197265625 0.007203122 0.99609375 0.00720834 0.99609375 0.007208342 0.98876953125 0.00721354 0.98876953125 0.007213542 0.982666015625 0.00721876 0.982666015625 0.007218762 0.9765625 0.00722396 0.9765625 0.007223962 0.96923828125 0.00722916 0.96923828125 0.007229162 0.963134765625 0.00723438 0.963134765625 0.007234382 0.95703125 0.00723958 0.95703125 0.007239582 0.94970703125 0.0072448 0.94970703125 0.007244802 0.943603515625 0.00725 0.943603515625 0.007250002 0.9375 0.0072552 0.9375 0.007255202 0.93017578125 0.00726042 0.93017578125 0.007260422 0.924072265625 0.00726562 0.924072265625 0.007265622 0.91796875 0.00727084 0.91796875 0.007270842 0.91064453125 0.00727604 0.91064453125 0.007276042 0.904541015625 0.00728124 0.904541015625 0.007281242 0.8984375 0.00728646 0.8984375 0.007286462 0.89111328125 0.00729166 0.89111328125 0.007291662 0.885009765625 0.00729688 0.885009765625 0.007296882 0.87890625 0.00730208 0.87890625 0.007302082 0.87158203125 0.0073073 0.87158203125 0.007307302 0.865478515625 0.0073125 0.865478515625 0.007312502 0.859375 0.0073177 0.859375 0.007317702 0.853271484375 0.00732292 0.853271484375 0.007322922 0.845947265625 0.00732812 0.845947265625 0.007328122 0.83984375 0.00733334 0.83984375 0.007333342 0.83251953125 0.00733854 0.83251953125 0.007338542 0.826416015625 0.00734376 0.826416015625 0.007343762 0.8203125 0.00734896 0.8203125 0.007348962 0.814208984375 0.00735416 0.814208984375 0.007354162 0.806884765625 0.00735938 0.806884765625 0.007359382 0.80078125 0.00736458 0.80078125 0.007364582 0.794677734375 0.0073698 0.794677734375 0.007369802 0.787353515625 0.007375 0.787353515625 0.007375002 0.78125 0.0073802 0.78125 0.007380202 0.775146484375 0.00738542 0.775146484375 0.007385422 0.767822265625 0.00739062 0.767822265625 0.007390622 0.76171875 0.00739584 0.76171875 0.007395842 0.755615234375 0.00740104 0.755615234375 0.007401042 0.748291015625 0.00740624 0.748291015625 0.007406242 0.7421875 0.00741146 0.7421875 0.007411462 0.736083984375 0.00741666 0.736083984375 0.007416662 0.728759765625 0.00742188 0.728759765625 0.007421882 0.72265625 0.00742708 0.72265625 0.007427082 0.716552734375 0.0074323 0.716552734375 0.007432302 0.709228515625 0.0074375 0.709228515625 0.007437502 0.703125 0.0074427 0.703125 0.007442702 0.697021484375 0.00744792 0.697021484375 0.007447922 0.689697265625 0.00745312 0.689697265625 0.007453122 0.68359375 0.00745834 0.68359375 0.007458342 0.677490234375 0.00746354 0.677490234375 0.007463542 0.670166015625 0.00746876 0.670166015625 0.007468762 0.6640625 0.00747396 0.6640625 0.007473962 0.657958984375 0.00747916 0.657958984375 0.007479162 0.650634765625 0.00748438 0.650634765625 0.007484382 0.64453125 0.00748958 0.64453125 0.007489582 0.638427734375 0.0074948 0.638427734375 0.007494802 0.631103515625 0.0075 0.631103515625 0.007500002 0.625 0.0075052 0.625 0.007505202 0.618896484375 0.00751042 0.618896484375 0.007510422 0.611572265625 0.00751562 0.611572265625 0.007515622 0.60546875 0.00752084 0.60546875 0.007520842 0.599365234375 0.00752604 0.599365234375 0.007526042 0.592041015625 0.00753124 0.592041015625 0.007531242 0.5859375 0.00753646 0.5859375 0.007536462 0.579833984375 0.00754166 0.579833984375 0.007541662 0.572509765625 0.00754688 0.572509765625 0.007546882 0.56640625 0.00755208 0.56640625 0.007552082 0.560302734375 0.0075573 0.560302734375 0.007557302 0.552978515625 0.0075625 0.552978515625 0.007562502 0.546875 0.0075677 0.546875 0.007567702 0.540771484375 0.00757292 0.540771484375 0.007572922 0.533447265625 0.00757812 0.533447265625 0.007578122 0.52734375 0.00758334 0.52734375 0.007583342 0.521240234375 0.00758854 0.521240234375 0.007588542 0.513916015625 0.00759376 0.513916015625 0.007593762 0.5078125 0.00759896 0.5078125 0.007598962 0.501708984375 0.00760416 0.501708984375 0.007604162 0.494384765625 0.00760938 0.494384765625 0.007609382 0.48828125 0.00761458 0.48828125 0.007614582 0.482177734375 0.0076198 0.482177734375 0.007619802 0.474853515625 0.007625 0.474853515625 0.007625002 0.46875 0.0076302 0.46875 0.007630202 0.462646484375 0.00763542 0.462646484375 0.007635422 0.455322265625 0.00764062 0.455322265625 0.007640622 0.44921875 0.00764584 0.44921875 0.007645842 0.443115234375 0.00765104 0.443115234375 0.007651042 0.435791015625 0.00765624 0.435791015625 0.007656242 0.4296875 0.00766146 0.4296875 0.007661462 0.423583984375 0.00766666 0.423583984375 0.007666662 0.416259765625 0.00767188 0.416259765625 0.007671882 0.41015625 0.00767708 0.41015625 0.007677082 0.404052734375 0.0076823 0.404052734375 0.007682302 0.396728515625 0.0076875 0.396728515625 0.007687502 0.390625 0.0076927 0.390625 0.007692702 0.384521484375 0.00769792 0.384521484375 0.007697922 0.377197265625 0.00770312 0.377197265625 0.007703122 0.37109375 0.00770834 0.37109375 0.007708342 0.364990234375 0.00771354 0.364990234375 0.007713542 0.357666015625 0.00771876 0.357666015625 0.007718762 0.3515625 0.00772396 0.3515625 0.007723962 0.345458984375 0.00772916 0.345458984375 0.007729162 0.338134765625 0.00773438 0.338134765625 0.007734382 0.33203125 0.00773958 0.33203125 0.007739582 0.325927734375 0.0077448 0.325927734375 0.007744802 0.318603515625 0.00775 0.318603515625 0.007750002 0.3125 0.0077552 0.3125 0.007755202 0.306396484375 0.00776042 0.306396484375 0.007760422 0.299072265625 0.00776562 0.299072265625 0.007765622 0.29296875 0.00777084 0.29296875 0.007770842 0.286865234375 0.00777604 0.286865234375 0.007776042 0.279541015625 0.00778124 0.279541015625 0.007781242 0.2734375 0.00778646 0.2734375 0.007786462 0.267333984375 0.00779166 0.267333984375 0.007791662 0.260009765625 0.00779688 0.260009765625 0.007796882 0.25390625 0.00780208 0.25390625 0.007802082 0.247802734375 0.0078073 0.247802734375 0.007807302 0.240478515625 0.0078125 0.240478515625 0.007812502 0.234375 0.0078177 0.234375 0.007817702 0.228271484375 0.00782292 0.228271484375 0.007822922 0.220947265625 0.00782812 0.220947265625 0.007828122 0.21484375 0.00783334 0.21484375 0.007833342 0.208740234375 0.00783854 0.208740234375 0.007838542 0.201416015625 0.00784376 0.201416015625 0.007843762 0.1953125 0.00784896 0.1953125 0.007848962 0.189208984375 0.00785416 0.189208984375 0.007854162 0.181884765625 0.00785938 0.181884765625 0.007859382 0.17578125 0.00786458 0.17578125 0.007864582 0.169677734375 0.0078698 0.169677734375 0.007869802 0.162353515625 0.007875 0.162353515625 0.007875002 0.15625 0.0078802 0.15625 0.007880202 0.150146484375 0.00788542 0.150146484375 0.007885422 0.142822265625 0.00789062 0.142822265625 0.007890622 0.13671875 0.00789584 0.13671875 0.007895842 0.130615234375 0.00790104 0.130615234375 0.007901042 0.123291015625 0.00790624 0.123291015625 0.007906242 0.1171875 0.00791146 0.1171875 0.007911462 0.111083984375 0.00791666 0.111083984375 0.007916662 0.103759765625 0.00792188 0.103759765625 0.007921882 0.09765625 0.00792708 0.09765625 0.007927082 0.091552734375 0.0079323 0.091552734375 0.007932302 0.084228515625 0.0079375 0.084228515625 0.007937502 0.078125 0.0079427 0.078125 0.007942702 0.072021484375 0.00794792 0.072021484375 0.007947922 0.064697265625 0.00795312 0.064697265625 0.007953122 0.05859375 0.00795834 0.05859375 0.007958342 0.052490234375 0.00796354 0.052490234375 0.007963542 0.045166015625 0.00796876 0.045166015625 0.007968762 0.0390625 0.00797396 0.0390625 0.007973962 0.032958984375 0.00797916 0.032958984375 0.007979162 0.025634765625 0.00798438 0.025634765625 0.007984382 0.01953125 0.00798958 0.01953125 0.007989582 0.013427734375 0.0079948 0.013427734375 0.007994802 0.006103515625 0.008 0.006103515625 0.008000002 0 0.0100052 0 0.010005202 0.006103515625 0.01001042 0.006103515625 0.010010422 0.013427734375 0.01001562 0.013427734375 0.010015622 0.01953125 0.01002084 0.01953125 0.010020842 0.025634765625 0.01002604 0.025634765625 0.010026042 0.032958984375 0.01003124 0.032958984375 0.010031242 0.0390625 0.01003646 0.0390625 0.010036462 0.045166015625 0.01004166 0.045166015625 0.010041662 0.052490234375 0.01004688 0.052490234375 0.010046882 0.05859375 0.01005208 0.05859375 0.010052082 0.064697265625 0.0100573 0.064697265625 0.010057302 0.072021484375 0.0100625 0.072021484375 0.010062502 0.078125 0.0100677 0.078125 0.010067702 0.084228515625 0.01007292 0.084228515625 0.010072922 0.091552734375 0.01007812 0.091552734375 0.010078122 0.09765625 0.01008334 0.09765625 0.010083342 0.103759765625 0.01008854 0.103759765625 0.010088542 0.111083984375 0.01009376 0.111083984375 0.010093762 0.1171875 0.01009896 0.1171875 0.010098962 0.123291015625 0.01010416 0.123291015625 0.010104162 0.130615234375 0.01010938 0.130615234375 0.010109382 0.13671875 0.01011458 0.13671875 0.010114582 0.142822265625 0.0101198 0.142822265625 0.010119802 0.150146484375 0.010125 0.150146484375 0.010125002 0.15625 0.0101302 0.15625 0.010130202 0.162353515625 0.01013542 0.162353515625 0.010135422 0.169677734375 0.01014062 0.169677734375 0.010140622 0.17578125 0.01014584 0.17578125 0.010145842 0.181884765625 0.01015104 0.181884765625 0.010151042 0.189208984375 0.01015624 0.189208984375 0.010156242 0.1953125 0.01016146 0.1953125 0.010161462 0.201416015625 0.01016666 0.201416015625 0.010166662 0.208740234375 0.01017188 0.208740234375 0.010171882 0.21484375 0.01017708 0.21484375 0.010177082 0.220947265625 0.0101823 0.220947265625 0.010182302 0.228271484375 0.0101875 0.228271484375 0.010187502 0.234375 0.0101927 0.234375 0.010192702 0.240478515625 0.01019792 0.240478515625 0.010197922 0.247802734375 0.01020312 0.247802734375 0.010203122 0.25390625 0.01020834 0.25390625 0.010208342 0.260009765625 0.01021354 0.260009765625 0.010213542 0.267333984375 0.01021876 0.267333984375 0.010218762 0.2734375 0.01022396 0.2734375 0.010223962 0.279541015625 0.01022916 0.279541015625 0.010229162 0.286865234375 0.01023438 0.286865234375 0.010234382 0.29296875 0.01023958 0.29296875 0.010239582 0.299072265625 0.0102448 0.299072265625 0.010244802 0.306396484375 0.01025 0.306396484375 0.010250002 0.3125 0.0102552 0.3125 0.010255202 0.318603515625 0.01026042 0.318603515625 0.010260422 0.325927734375 0.01026562 0.325927734375 0.010265622 0.33203125 0.01027084 0.33203125 0.010270842 0.338134765625 0.01027604 0.338134765625 0.010276042 0.345458984375 0.01028124 0.345458984375 0.010281242 0.3515625 0.01028646 0.3515625 0.010286462 0.357666015625 0.01029166 0.357666015625 0.010291662 0.364990234375 0.01029688 0.364990234375 0.010296882 0.37109375 0.01030208 0.37109375 0.010302082 0.377197265625 0.0103073 0.377197265625 0.010307302 0.384521484375 0.0103125 0.384521484375 0.010312502 0.390625 0.0103177 0.390625 0.010317702 0.396728515625 0.01032292 0.396728515625 0.010322922 0.404052734375 0.01032812 0.404052734375 0.010328122 0.41015625 0.01033334 0.41015625 0.010333342 0.416259765625 0.01033854 0.416259765625 0.010338542 0.423583984375 0.01034376 0.423583984375 0.010343762 0.4296875 0.01034896 0.4296875 0.010348962 0.435791015625 0.01035416 0.435791015625 0.010354162 0.443115234375 0.01035938 0.443115234375 0.010359382 0.44921875 0.01036458 0.44921875 0.010364582 0.455322265625 0.0103698 0.455322265625 0.010369802 0.462646484375 0.010375 0.462646484375 0.010375002 0.46875 0.0103802 0.46875 0.010380202 0.474853515625 0.01038542 0.474853515625 0.010385422 0.482177734375 0.01039062 0.482177734375 0.010390622 0.48828125 0.01039584 0.48828125 0.010395842 0.494384765625 0.01040104 0.494384765625 0.010401042 0.501708984375 0.01040624 0.501708984375 0.010406242 0.5078125 0.01041146 0.5078125 0.010411462 0.513916015625 0.01041666 0.513916015625 0.010416662 0.521240234375 0.01042188 0.521240234375 0.010421882 0.52734375 0.01042708 0.52734375 0.010427082 0.533447265625 0.0104323 0.533447265625 0.010432302 0.540771484375 0.0104375 0.540771484375 0.010437502 0.546875 0.0104427 0.546875 0.010442702 0.552978515625 0.01044792 0.552978515625 0.010447922 0.560302734375 0.01045312 0.560302734375 0.010453122 0.56640625 0.01045834 0.56640625 0.010458342 0.572509765625 0.01046354 0.572509765625 0.010463542 0.579833984375 0.01046876 0.579833984375 0.010468762 0.5859375 0.01047396 0.5859375 0.010473962 0.592041015625 0.01047916 0.592041015625 0.010479162 0.599365234375 0.01048438 0.599365234375 0.010484382 0.60546875 0.01048958 0.60546875 0.010489582 0.611572265625 0.0104948 0.611572265625 0.010494802 0.618896484375 0.0105 0.618896484375 0.010500002 0.625 0.0105052 0.625 0.010505202 0.631103515625 0.01051042 0.631103515625 0.010510422 0.638427734375 0.01051562 0.638427734375 0.010515622 0.64453125 0.01052084 0.64453125 0.010520842 0.650634765625 0.01052604 0.650634765625 0.010526042 0.657958984375 0.01053124 0.657958984375 0.010531242 0.6640625 0.01053646 0.6640625 0.010536462 0.670166015625 0.01054166 0.670166015625 0.010541662 0.677490234375 0.01054688 0.677490234375 0.010546882 0.68359375 0.01055208 0.68359375 0.010552082 0.689697265625 0.0105573 0.689697265625 0.010557302 0.697021484375 0.0105625 0.697021484375 0.010562502 0.703125 0.0105677 0.703125 0.010567702 0.709228515625 0.01057292 0.709228515625 0.010572922 0.716552734375 0.01057812 0.716552734375 0.010578122 0.72265625 0.01058334 0.72265625 0.010583342 0.728759765625 0.01058854 0.728759765625 0.010588542 0.736083984375 0.01059376 0.736083984375 0.010593762 0.7421875 0.01059896 0.7421875 0.010598962 0.748291015625 0.01060416 0.748291015625 0.010604162 0.755615234375 0.01060938 0.755615234375 0.010609382 0.76171875 0.01061458 0.76171875 0.010614582 0.767822265625 0.0106198 0.767822265625 0.010619802 0.775146484375 0.010625 0.775146484375 0.010625002 0.78125 0.0106302 0.78125 0.010630202 0.787353515625 0.01063542 0.787353515625 0.010635422 0.794677734375 0.01064062 0.794677734375 0.010640622 0.80078125 0.01064584 0.80078125 0.010645842 0.806884765625 0.01065104 0.806884765625 0.010651042 0.814208984375 0.01065624 0.814208984375 0.010656242 0.8203125 0.01066146 0.8203125 0.010661462 0.826416015625 0.01066666 0.826416015625 0.010666662 0.83251953125 0.01067188 0.83251953125 0.010671882 0.83984375 0.01067708 0.83984375 0.010677082 0.845947265625 0.0106823 0.845947265625 0.010682302 0.853271484375 0.0106875 0.853271484375 0.010687502 0.859375 0.0106927 0.859375 0.010692702 0.865478515625 0.01069792 0.865478515625 0.010697922 0.87158203125 0.01070312 0.87158203125 0.010703122 0.87890625 0.01070834 0.87890625 0.010708342 0.885009765625 0.01071354 0.885009765625 0.010713542 0.89111328125 0.01071876 0.89111328125 0.010718762 0.8984375 0.01072396 0.8984375 0.010723962 0.904541015625 0.01072916 0.904541015625 0.010729162 0.91064453125 0.01073438 0.91064453125 0.010734382 0.91796875 0.01073958 0.91796875 0.010739582 0.924072265625 0.0107448 0.924072265625 0.010744802 0.93017578125 0.01075 0.93017578125 0.010750002 0.9375 0.0107552 0.9375 0.010755202 0.943603515625 0.01076042 0.943603515625 0.010760422 0.94970703125 0.01076562 0.94970703125 0.010765622 0.95703125 0.01077084 0.95703125 0.010770842 0.963134765625 0.01077604 0.963134765625 0.010776042 0.96923828125 0.01078124 0.96923828125 0.010781242 0.9765625 0.01078646 0.9765625 0.010786462 0.982666015625 0.01079166 0.982666015625 0.010791662 0.98876953125 0.01079688 0.98876953125 0.010796882 0.99609375 0.01080208 0.99609375 0.010802082 1.002197265625 0.0108073 1.002197265625 0.010807302 1.00830078125 0.0108125 1.00830078125 0.010812502 1.015625 0.0108177 1.015625 0.010817702 1.021728515625 0.01082292 1.021728515625 0.010822922 1.02783203125 0.01082812 1.02783203125 0.010828122 1.03515625 0.01083334 1.03515625 0.010833342 1.041259765625 0.01083854 1.041259765625 0.010838542 1.04736328125 0.01084376 1.04736328125 0.010843762 1.0546875 0.01084896 1.0546875 0.010848962 1.060791015625 0.01085416 1.060791015625 0.010854162 1.06689453125 0.01085938 1.06689453125 0.010859382 1.07421875 0.01086458 1.07421875 0.010864582 1.080322265625 0.0108698 1.080322265625 0.010869802 1.08642578125 0.010875 1.08642578125 0.010875002 1.09375 0.0108802 1.09375 0.010880202 1.099853515625 0.01088542 1.099853515625 0.010885422 1.10595703125 0.01089062 1.10595703125 0.010890622 1.11328125 0.01089584 1.11328125 0.010895842 1.119384765625 0.01090104 1.119384765625 0.010901042 1.12548828125 0.01090624 1.12548828125 0.010906242 1.1328125 0.01091146 1.1328125 0.010911462 1.138916015625 0.01091666 1.138916015625 0.010916662 1.14501953125 0.01092188 1.14501953125 0.010921882 1.15234375 0.01092708 1.15234375 0.010927082 1.158447265625 0.0109323 1.158447265625 0.010932302 1.16455078125 0.0109375 1.16455078125 0.010937502 1.171875 0.0109427 1.171875 0.010942702 1.177978515625 0.01094792 1.177978515625 0.010947922 1.18408203125 0.01095312 1.18408203125 0.010953122 1.19140625 0.01095834 1.19140625 0.010958342 1.197509765625 0.01096354 1.197509765625 0.010963542 1.20361328125 0.01096876 1.20361328125 0.010968762 1.2109375 0.01097396 1.2109375 0.010973962 1.217041015625 0.01097916 1.217041015625 0.010979162 1.22314453125 0.01098438 1.22314453125 0.010984382 1.23046875 0.01098958 1.23046875 0.010989582 1.236572265625 0.0109948 1.236572265625 0.010994802 1.24267578125 0.011 1.24267578125 0.011000002 1.25 0.0110052 1.25 0.011005202 1.256103515625 0.01101042 1.256103515625 0.011010422 1.26220703125 0.01101562 1.26220703125 0.011015622 1.26953125 0.01102084 1.26953125 0.011020842 1.275634765625 0.01102604 1.275634765625 0.011026042 1.28173828125 0.01103124 1.28173828125 0.011031242 1.2890625 0.01103646 1.2890625 0.011036462 1.295166015625 0.01104166 1.295166015625 0.011041662 1.30126953125 0.01104688 1.30126953125 0.011046882 1.30859375 0.01105208 1.30859375 0.011052082 1.314697265625 0.0110573 1.314697265625 0.011057302 1.32080078125 0.0110625 1.32080078125 0.011062502 1.328125 0.0110677 1.328125 0.011067702 1.334228515625 0.01107292 1.334228515625 0.011072922 1.34033203125 0.01107812 1.34033203125 0.011078122 1.34765625 0.01108334 1.34765625 0.011083342 1.353759765625 0.01108854 1.353759765625 0.011088542 1.35986328125 0.01109376 1.35986328125 0.011093762 1.3671875 0.01109896 1.3671875 0.011098962 1.373291015625 0.01110416 1.373291015625 0.011104162 1.37939453125 0.01110938 1.37939453125 0.011109382 1.38671875 0.01111458 1.38671875 0.011114582 1.392822265625 0.0111198 1.392822265625 0.011119802 1.39892578125 0.011125 1.39892578125 0.011125002 1.40625 0.0111302 1.40625 0.011130202 1.412353515625 0.01113542 1.412353515625 0.011135422 1.41845703125 0.01114062 1.41845703125 0.011140622 1.42578125 0.01114584 1.42578125 0.011145842 1.431884765625 0.01115104 1.431884765625 0.011151042 1.43798828125 0.01115624 1.43798828125 0.011156242 1.4453125 0.01116146 1.4453125 0.011161462 1.451416015625 0.01116666 1.451416015625 0.011166662 1.45751953125 0.01117188 1.45751953125 0.011171882 1.46484375 0.01117708 1.46484375 0.011177082 1.470947265625 0.0111823 1.470947265625 0.011182302 1.47705078125 0.0111875 1.47705078125 0.011187502 1.484375 0.0111927 1.484375 0.011192702 1.490478515625 0.01119792 1.490478515625 0.011197922 1.49658203125 0.01120312 1.49658203125 0.011203122 1.50390625 0.01120834 1.50390625 0.011208342 1.510009765625 0.01121354 1.510009765625 0.011213542 1.51611328125 0.01121876 1.51611328125 0.011218762 1.5234375 0.01122396 1.5234375 0.011223962 1.529541015625 0.01122916 1.529541015625 0.011229162 1.53564453125 0.01123438 1.53564453125 0.011234382 1.54296875 0.01123958 1.54296875 0.011239582 1.549072265625 0.0112448 1.549072265625 0.011244802 1.55517578125 0.01125 1.55517578125 0.011250002 1.5625 0.0112552 1.5625 0.011255202 1.568603515625 0.01126042 1.568603515625 0.011260422 1.57470703125 0.01126562 1.57470703125 0.011265622 1.58203125 0.01127084 1.58203125 0.011270842 1.588134765625 0.01127604 1.588134765625 0.011276042 1.59423828125 0.01128124 1.59423828125 0.011281242 1.6015625 0.01128646 1.6015625 0.011286462 1.607666015625 0.01129166 1.607666015625 0.011291662 1.61376953125 0.01129688 1.61376953125 0.011296882 1.62109375 0.01130208 1.62109375 0.011302082 1.627197265625 0.0113073 1.627197265625 0.011307302 1.63330078125 0.0113125 1.63330078125 0.011312502 1.640625 0.0113177 1.640625 0.011317702 1.646728515625 0.01132292 1.646728515625 0.011322922 1.65283203125 0.01132812 1.65283203125 0.011328122 1.66015625 0.01133334 1.66015625 0.011333342 1.666259765625 0.01133854 1.666259765625 0.011338542 1.67236328125 0.01134376 1.67236328125 0.011343762 1.6796875 0.01134896 1.6796875 0.011348962 1.685791015625 0.01135416 1.685791015625 0.011354162 1.69189453125 0.01135938 1.69189453125 0.011359382 1.69921875 0.01136458 1.69921875 0.011364582 1.705322265625 0.0113698 1.705322265625 0.011369802 1.71142578125 0.011375 1.71142578125 0.011375002 1.71875 0.0113802 1.71875 0.011380202 1.724853515625 0.01138542 1.724853515625 0.011385422 1.73095703125 0.01139062 1.73095703125 0.011390622 1.73828125 0.01139584 1.73828125 0.011395842 1.744384765625 0.01140104 1.744384765625 0.011401042 1.75048828125 0.01140624 1.75048828125 0.011406242 1.7578125 0.01141146 1.7578125 0.011411462 1.763916015625 0.01141666 1.763916015625 0.011416662 1.77001953125 0.01142188 1.77001953125 0.011421882 1.77734375 0.01142708 1.77734375 0.011427082 1.783447265625 0.0114323 1.783447265625 0.011432302 1.78955078125 0.0114375 1.78955078125 0.011437502 1.796875 0.0114427 1.796875 0.011442702 1.802978515625 0.01144792 1.802978515625 0.011447922 1.80908203125 0.01145312 1.80908203125 0.011453122 1.81640625 0.01145834 1.81640625 0.011458342 1.822509765625 0.01146354 1.822509765625 0.011463542 1.82861328125 0.01146876 1.82861328125 0.011468762 1.8359375 0.01147396 1.8359375 0.011473962 1.842041015625 0.01147916 1.842041015625 0.011479162 1.84814453125 0.01148438 1.84814453125 0.011484382 1.85546875 0.01148958 1.85546875 0.011489582 1.861572265625 0.0114948 1.861572265625 0.011494802 1.86767578125 0.0115 1.86767578125 0.011500002 1.875 0.0115052 1.875 0.011505202 1.881103515625 0.01151042 1.881103515625 0.011510422 1.88720703125 0.01151562 1.88720703125 0.011515622 1.89453125 0.01152084 1.89453125 0.011520842 1.900634765625 0.01152604 1.900634765625 0.011526042 1.90673828125 0.01153124 1.90673828125 0.011531242 1.9140625 0.01153646 1.9140625 0.011536462 1.920166015625 0.01154166 1.920166015625 0.011541662 1.92626953125 0.01154688 1.92626953125 0.011546882 1.93359375 0.01155208 1.93359375 0.011552082 1.939697265625 0.0115573 1.939697265625 0.011557302 1.94580078125 0.0115625 1.94580078125 0.011562502 1.953125 0.0115677 1.953125 0.011567702 1.959228515625 0.01157292 1.959228515625 0.011572922 1.96533203125 0.01157812 1.96533203125 0.011578122 1.97265625 0.01158334 1.97265625 0.011583342 1.978759765625 0.01158854 1.978759765625 0.011588542 1.98486328125 0.01159376 1.98486328125 0.011593762 1.9921875 0.01159896 1.9921875 0.011598962 1.998291015625 0.01160416 1.998291015625 0.011604162 2.00439453125 0.01160938 2.00439453125 0.011609382 2.01171875 0.01161458 2.01171875 0.011614582 2.017822265625 0.0116198 2.017822265625 0.011619802 2.02392578125 0.011625 2.02392578125 0.011625002 2.03125 0.0116302 2.03125 0.011630202 2.037353515625 0.01163542 2.037353515625 0.011635422 2.04345703125 0.01164062 2.04345703125 0.011640622 2.05078125 0.01164584 2.05078125 0.011645842 2.056884765625 0.01165104 2.056884765625 0.011651042 2.06298828125 0.01165624 2.06298828125 0.011656242 2.0703125 0.01166146 2.0703125 0.011661462 2.076416015625 0.01166666 2.076416015625 0.011666662 2.08251953125 0.01167188 2.08251953125 0.011671882 2.08984375 0.01167708 2.08984375 0.011677082 2.095947265625 0.0116823 2.095947265625 0.011682302 2.10205078125 0.0116875 2.10205078125 0.011687502 2.109375 0.0116927 2.109375 0.011692702 2.115478515625 0.01169792 2.115478515625 0.011697922 2.12158203125 0.01170312 2.12158203125 0.011703122 2.12890625 0.01170834 2.12890625 0.011708342 2.135009765625 0.01171354 2.135009765625 0.011713542 2.14111328125 0.01171876 2.14111328125 0.011718762 2.1484375 0.01172396 2.1484375 0.011723962 2.154541015625 0.01172916 2.154541015625 0.011729162 2.16064453125 0.01173438 2.16064453125 0.011734382 2.16796875 0.01173958 2.16796875 0.011739582 2.174072265625 0.0117448 2.174072265625 0.011744802 2.18017578125 0.01175 2.18017578125 0.011750002 2.1875 0.0117552 2.1875 0.011755202 2.193603515625 0.01176042 2.193603515625 0.011760422 2.19970703125 0.01176562 2.19970703125 0.011765622 2.20703125 0.01177084 2.20703125 0.011770842 2.213134765625 0.01177604 2.213134765625 0.011776042 2.21923828125 0.01178124 2.21923828125 0.011781242 2.2265625 0.01178646 2.2265625 0.011786462 2.232666015625 0.01179166 2.232666015625 0.011791662 2.23876953125 0.01179688 2.23876953125 0.011796882 2.24609375 0.01180208 2.24609375 0.011802082 2.252197265625 0.0118073 2.252197265625 0.011807302 2.25830078125 0.0118125 2.25830078125 0.011812502 2.265625 0.0118177 2.265625 0.011817702 2.271728515625 0.01182292 2.271728515625 0.011822922 2.27783203125 0.01182812 2.27783203125 0.011828122 2.28515625 0.01183334 2.28515625 0.011833342 2.291259765625 0.01183854 2.291259765625 0.011838542 2.29736328125 0.01184376 2.29736328125 0.011843762 2.3046875 0.01184896 2.3046875 0.011848962 2.310791015625 0.01185416 2.310791015625 0.011854162 2.31689453125 0.01185938 2.31689453125 0.011859382 2.32421875 0.01186458 2.32421875 0.011864582 2.330322265625 0.0118698 2.330322265625 0.011869802 2.33642578125 0.011875 2.33642578125 0.011875002 2.34375 0.0118802 2.34375 0.011880202 2.349853515625 0.01188542 2.349853515625 0.011885422 2.35595703125 0.01189062 2.35595703125 0.011890622 2.36328125 0.01189584 2.36328125 0.011895842 2.369384765625 0.01190104 2.369384765625 0.011901042 2.37548828125 0.01190624 2.37548828125 0.011906242 2.3828125 0.01191146 2.3828125 0.011911462 2.388916015625 0.01191666 2.388916015625 0.011916662 2.39501953125 0.01192188 2.39501953125 0.011921882 2.40234375 0.01192708 2.40234375 0.011927082 2.408447265625 0.0119323 2.408447265625 0.011932302 2.41455078125 0.0119375 2.41455078125 0.011937502 2.421875 0.0119427 2.421875 0.011942702 2.427978515625 0.01194792 2.427978515625 0.011947922 2.43408203125 0.01195312 2.43408203125 0.011953122 2.44140625 0.01195834 2.44140625 0.011958342 2.447509765625 0.01196354 2.447509765625 0.011963542 2.45361328125 0.01196876 2.45361328125 0.011968762 2.4609375 0.01197396 2.4609375 0.011973962 2.467041015625 0.01197916 2.467041015625 0.011979162 2.47314453125 0.01198438 2.47314453125 0.011984382 2.48046875 0.01198958 2.48046875 0.011989582 2.486572265625 0.0119948 2.486572265625 0.011994802 2.49267578125 0.012 2.49267578125 0.012000002 2.5 0.0120052 2.5 0.012005202 2.5048828125 0.01201042 2.5048828125 0.012010422 2.510986328125 0.01201562 2.510986328125 0.012015622 2.51708984375 0.01202084 2.51708984375 0.012020842 2.523193359375 0.01202604 2.523193359375 0.012026042 2.528076171875 0.01203124 2.528076171875 0.012031242 2.5341796875 0.01203646 2.5341796875 0.012036462 2.5390625 0.01204166 2.5390625 0.012041662 2.545166015625 0.01204688 2.545166015625 0.012046882 2.550048828125 0.01205208 2.550048828125 0.012052082 2.554931640625 0.0120573 2.554931640625 0.012057302 2.559814453125 0.0120625 2.559814453125 0.012062502 2.564697265625 0.0120677 2.564697265625 0.012067702 2.568359375 0.01207292 2.568359375 0.012072922 2.5732421875 0.01207812 2.5732421875 0.012078122 2.576904296875 0.01208334 2.576904296875 0.012083342 2.58056640625 0.01208854 2.58056640625 0.012088542 2.584228515625 0.01209376 2.584228515625 0.012093762 2.586669921875 0.01209896 2.586669921875 0.012098962 2.59033203125 0.01210416 2.59033203125 0.012104162 2.5927734375 0.01210938 2.5927734375 0.012109382 2.593994140625 0.01211458 2.593994140625 0.012114582 2.596435546875 0.0121198 2.596435546875 0.012119802 2.59765625 0.012125 2.59765625 0.012125002 2.598876953125 0.0121302 2.598876953125 0.012130202 2.60009765625 0.01214584 2.60009765625 0.012145842 2.598876953125 0.01215624 2.598876953125 0.012156242 2.596435546875 0.01216146 2.596435546875 0.012161462 2.59521484375 0.01216666 2.59521484375 0.012166662 2.5927734375 0.01217188 2.5927734375 0.012171882 2.59033203125 0.01217708 2.59033203125 0.012177082 2.587890625 0.0121823 2.587890625 0.012182302 2.584228515625 0.0121875 2.584228515625 0.012187502 2.58056640625 0.0121927 2.58056640625 0.012192702 2.57568359375 0.01219792 2.57568359375 0.012197922 2.57080078125 0.01220312 2.57080078125 0.012203122 2.56591796875 0.01220834 2.56591796875 0.012208342 2.559814453125 0.01221354 2.559814453125 0.012213542 2.5537109375 0.01221876 2.5537109375 0.012218762 2.547607421875 0.01222396 2.547607421875 0.012223962 2.540283203125 0.01222916 2.540283203125 0.012229162 2.532958984375 0.01223438 2.532958984375 0.012234382 2.525634765625 0.01223958 2.525634765625 0.012239582 2.51708984375 0.0122448 2.51708984375 0.012244802 2.508544921875 0.01225 2.508544921875 0.012250002 2.5 0.0122552 2.5 0.012255202 2.490234375 0.01226042 2.490234375 0.012260422 2.48046875 0.01226562 2.48046875 0.012265622 2.470703125 0.01227084 2.470703125 0.012270842 2.459716796875 0.01227604 2.459716796875 0.012276042 2.44873046875 0.01228124 2.44873046875 0.012281242 2.437744140625 0.01228646 2.437744140625 0.012286462 2.4267578125 0.01229166 2.4267578125 0.012291662 2.41455078125 0.01229688 2.41455078125 0.012296882 2.40234375 0.01230208 2.40234375 0.012302082 2.39013671875 0.0123073 2.39013671875 0.012307302 2.3779296875 0.0123125 2.3779296875 0.012312502 2.364501953125 0.0123177 2.364501953125 0.012317702 2.352294921875 0.01232292 2.352294921875 0.012322922 2.3388671875 0.01232812 2.3388671875 0.012328122 2.325439453125 0.01233334 2.325439453125 0.012333342 2.31201171875 0.01233854 2.31201171875 0.012338542 2.298583984375 0.01234376 2.298583984375 0.012343762 2.28515625 0.01234896 2.28515625 0.012348962 2.2705078125 0.01235416 2.2705078125 0.012354162 2.257080078125 0.01235938 2.257080078125 0.012359382 2.242431640625 0.01236458 2.242431640625 0.012364582 2.22900390625 0.0123698 2.22900390625 0.012369802 2.215576171875 0.012375 2.215576171875 0.012375002 2.200927734375 0.0123802 2.200927734375 0.012380202 2.1875 0.01238542 2.1875 0.012385422 2.174072265625 0.01239062 2.174072265625 0.012390622 2.159423828125 0.01239584 2.159423828125 0.012395842 2.14599609375 0.01240104 2.14599609375 0.012401042 2.132568359375 0.01240624 2.132568359375 0.012406242 2.119140625 0.01241146 2.119140625 0.012411462 2.10693359375 0.01241666 2.10693359375 0.012416662 2.093505859375 0.01242188 2.093505859375 0.012421882 2.081298828125 0.01242708 2.081298828125 0.012427082 2.069091796875 0.0124323 2.069091796875 0.012432302 2.056884765625 0.0124375 2.056884765625 0.012437502 2.044677734375 0.0124427 2.044677734375 0.012442702 2.03369140625 0.01244792 2.03369140625 0.012447922 2.022705078125 0.01245312 2.022705078125 0.012453122 2.01171875 0.01245834 2.01171875 0.012458342 2.001953125 0.01246354 2.001953125 0.012463542 1.9921875 0.01246876 1.9921875 0.012468762 1.982421875 0.01247396 1.982421875 0.012473962 1.973876953125 0.01247916 1.973876953125 0.012479162 1.96533203125 0.01248438 1.96533203125 0.012484382 1.956787109375 0.01248958 1.956787109375 0.012489582 1.949462890625 0.0124948 1.949462890625 0.012494802 1.943359375 0.0125 1.943359375 0.012500002 1.937255859375 0.0125052 1.937255859375 0.012505202 1.93115234375 0.01251042 1.93115234375 0.012510422 1.92626953125 0.01251562 1.92626953125 0.012515622 1.922607421875 0.01252084 1.922607421875 0.012520842 1.9189453125 0.01252604 1.9189453125 0.012526042 1.915283203125 0.01253124 1.915283203125 0.012531242 1.912841796875 0.01253646 1.912841796875 0.012536462 1.91162109375 0.01254166 1.91162109375 0.012541662 1.910400390625 0.01255208 1.910400390625 0.012552082 1.91162109375 0.0125573 1.91162109375 0.012557302 1.912841796875 0.0125625 1.912841796875 0.012562502 1.915283203125 0.0125677 1.915283203125 0.012567702 1.917724609375 0.01257292 1.917724609375 0.012572922 1.92138671875 0.01257812 1.92138671875 0.012578122 1.92626953125 0.01258334 1.92626953125 0.012583342 1.93115234375 0.01258854 1.93115234375 0.012588542 1.937255859375 0.01259376 1.937255859375 0.012593762 1.944580078125 0.01259896 1.944580078125 0.012598962 1.951904296875 0.01260416 1.951904296875 0.012604162 1.96044921875 0.01260938 1.96044921875 0.012609382 1.968994140625 0.01261458 1.968994140625 0.012614582 1.97998046875 0.0126198 1.97998046875 0.012619802 1.990966796875 0.012625 1.990966796875 0.012625002 2.001953125 0.0126302 2.001953125 0.012630202 2.015380859375 0.01263542 2.015380859375 0.012635422 2.027587890625 0.01264062 2.027587890625 0.012640622 2.042236328125 0.01264584 2.042236328125 0.012645842 2.056884765625 0.01265104 2.056884765625 0.012651042 2.07275390625 0.01265624 2.07275390625 0.012656242 2.08984375 0.01266146 2.08984375 0.012661462 2.10693359375 0.01266666 2.10693359375 0.012666662 2.1240234375 0.01267188 2.1240234375 0.012671882 2.1435546875 0.01267708 2.1435546875 0.012677082 2.1630859375 0.0126823 2.1630859375 0.012682302 2.1826171875 0.0126875 2.1826171875 0.012687502 2.203369140625 0.0126927 2.203369140625 0.012692702 2.225341796875 0.01269792 2.225341796875 0.012697922 2.247314453125 0.01270312 2.247314453125 0.012703122 2.269287109375 0.01270834 2.269287109375 0.012708342 2.293701171875 0.01271354 2.293701171875 0.012713542 2.31689453125 0.01271876 2.31689453125 0.012718762 2.34130859375 0.01272396 2.34130859375 0.012723962 2.366943359375 0.01272916 2.366943359375 0.012729162 2.392578125 0.01273438 2.392578125 0.012734382 2.418212890625 0.01273958 2.418212890625 0.012739582 2.445068359375 0.0127448 2.445068359375 0.012744802 2.471923828125 0.01275 2.471923828125 0.012750002 2.498779296875 0.0127552 2.498779296875 0.012755202 2.52685546875 0.01276042 2.52685546875 0.012760422 2.554931640625 0.01276562 2.554931640625 0.012765622 2.584228515625 0.01277084 2.584228515625 0.012770842 2.6123046875 0.01277604 2.6123046875 0.012776042 2.6416015625 0.01278124 2.6416015625 0.012781242 2.6708984375 0.01278646 2.6708984375 0.012786462 2.7001953125 0.01279166 2.7001953125 0.012791662 2.7294921875 0.01279688 2.7294921875 0.012796882 2.760009765625 0.01280208 2.760009765625 0.012802082 2.789306640625 0.0128073 2.789306640625 0.012807302 2.81982421875 0.0128125 2.81982421875 0.012812502 2.84912109375 0.0128177 2.84912109375 0.012817702 2.87841796875 0.01282292 2.87841796875 0.012822922 2.908935546875 0.01282812 2.908935546875 0.012828122 2.938232421875 0.01283334 2.938232421875 0.012833342 2.967529296875 0.01283854 2.967529296875 0.012838542 2.996826171875 0.01284376 2.996826171875 0.012843762 3.026123046875 0.01284896 3.026123046875 0.012848962 3.055419921875 0.01285416 3.055419921875 0.012854162 3.084716796875 0.01285938 3.084716796875 0.012859382 3.11279296875 0.01286458 3.11279296875 0.012864582 3.140869140625 0.0128698 3.140869140625 0.012869802 3.167724609375 0.012875 3.167724609375 0.012875002 3.19580078125 0.0128802 3.19580078125 0.012880202 3.221435546875 0.01288542 3.221435546875 0.012885422 3.248291015625 0.01289062 3.248291015625 0.012890622 3.27392578125 0.01289584 3.27392578125 0.012895842 3.29833984375 0.01290104 3.29833984375 0.012901042 3.32275390625 0.01290624 3.32275390625 0.012906242 3.34716796875 0.01291146 3.34716796875 0.012911462 3.370361328125 0.01291666 3.370361328125 0.012916662 3.392333984375 0.01292188 3.392333984375 0.012921882 3.414306640625 0.01292708 3.414306640625 0.012927082 3.43505859375 0.0129323 3.43505859375 0.012932302 3.45458984375 0.0129375 3.45458984375 0.012937502 3.47412109375 0.0129427 3.47412109375 0.012942702 3.4912109375 0.01294792 3.4912109375 0.012947922 3.509521484375 0.01295312 3.509521484375 0.012953122 3.525390625 0.01295834 3.525390625 0.012958342 3.5400390625 0.01296354 3.5400390625 0.012963542 3.5546875 0.01296876 3.5546875 0.012968762 3.568115234375 0.01297396 3.568115234375 0.012973962 3.580322265625 0.01297916 3.580322265625 0.012979162 3.59130859375 0.01298438 3.59130859375 0.012984382 3.60107421875 0.01298958 3.60107421875 0.012989582 3.609619140625 0.0129948 3.609619140625 0.012994802 3.6181640625 0.013 3.6181640625 0.013000002 3.624267578125 0.0130052 3.624267578125 0.013005202 3.629150390625 0.01301042 3.629150390625 0.013010422 3.6328125 0.01301562 3.6328125 0.013015622 3.636474609375 0.01302084 3.636474609375 0.013020842 3.6376953125 0.01303124 3.6376953125 0.013031242 3.636474609375 0.01303646 3.636474609375 0.013036462 3.63525390625 0.01304166 3.63525390625 0.013041662 3.631591796875 0.01304688 3.631591796875 0.013046882 3.626708984375 0.01305208 3.626708984375 0.013052082 3.619384765625 0.0130573 3.619384765625 0.013057302 3.612060546875 0.0130625 3.612060546875 0.013062502 3.603515625 0.0130677 3.603515625 0.013067702 3.59375 0.01307292 3.59375 0.013072922 3.58154296875 0.01307812 3.58154296875 0.013078122 3.5693359375 0.01308334 3.5693359375 0.013083342 3.5546875 0.01308854 3.5546875 0.013088542 3.538818359375 0.01309376 3.538818359375 0.013093762 3.521728515625 0.01309896 3.521728515625 0.013098962 3.504638671875 0.01310416 3.504638671875 0.013104162 3.485107421875 0.01310938 3.485107421875 0.013109382 3.46435546875 0.01311458 3.46435546875 0.013114582 3.4423828125 0.0131198 3.4423828125 0.013119802 3.419189453125 0.013125 3.419189453125 0.013125002 3.3935546875 0.0131302 3.3935546875 0.013130202 3.367919921875 0.01313542 3.367919921875 0.013135422 3.341064453125 0.01314062 3.341064453125 0.013140622 3.31298828125 0.01314584 3.31298828125 0.013145842 3.28369140625 0.01315104 3.28369140625 0.013151042 3.253173828125 0.01315624 3.253173828125 0.013156242 3.221435546875 0.01316146 3.221435546875 0.013161462 3.189697265625 0.01316666 3.189697265625 0.013166662 3.155517578125 0.01317188 3.155517578125 0.013171882 3.1201171875 0.01317708 3.1201171875 0.013177082 3.084716796875 0.0131823 3.084716796875 0.013182302 3.048095703125 0.0131875 3.048095703125 0.013187502 3.01025390625 0.0131927 3.01025390625 0.013192702 2.972412109375 0.01319792 2.972412109375 0.013197922 2.93212890625 0.01320312 2.93212890625 0.013203122 2.891845703125 0.01320834 2.891845703125 0.013208342 2.8515625 0.01321354 2.8515625 0.013213542 2.808837890625 0.01321876 2.808837890625 0.013218762 2.767333984375 0.01322396 2.767333984375 0.013223962 2.723388671875 0.01322916 2.723388671875 0.013229162 2.679443359375 0.01323438 2.679443359375 0.013234382 2.635498046875 0.01323958 2.635498046875 0.013239582 2.59033203125 0.0132448 2.59033203125 0.013244802 2.545166015625 0.01325 2.545166015625 0.013250002 2.5 0.0132552 2.5 0.013255202 2.45361328125 0.01326042 2.45361328125 0.013260422 2.4072265625 0.01326562 2.4072265625 0.013265622 2.359619140625 0.01327084 2.359619140625 0.013270842 2.313232421875 0.01327604 2.313232421875 0.013276042 2.265625 0.01328124 2.265625 0.013281242 2.218017578125 0.01328646 2.218017578125 0.013286462 2.17041015625 0.01329166 2.17041015625 0.013291662 2.1240234375 0.01329688 2.1240234375 0.013296882 2.076416015625 0.01330208 2.076416015625 0.013302082 2.02880859375 0.0133073 2.02880859375 0.013307302 1.981201171875 0.0133125 1.981201171875 0.013312502 1.934814453125 0.0133177 1.934814453125 0.013317702 1.88720703125 0.01332292 1.88720703125 0.013322922 1.8408203125 0.01332812 1.8408203125 0.013328122 1.795654296875 0.01333334 1.795654296875 0.013333342 1.749267578125 0.01333854 1.749267578125 0.013338542 1.7041015625 0.01334376 1.7041015625 0.013343762 1.66015625 0.01334896 1.66015625 0.013348962 1.6162109375 0.01335416 1.6162109375 0.013354162 1.572265625 0.01335938 1.572265625 0.013359382 1.529541015625 0.01336458 1.529541015625 0.013364582 1.488037109375 0.0133698 1.488037109375 0.013369802 1.446533203125 0.013375 1.446533203125 0.013375002 1.40625 0.0133802 1.40625 0.013380202 1.365966796875 0.01338542 1.365966796875 0.013385422 1.328125 0.01339062 1.328125 0.013390622 1.290283203125 0.01339584 1.290283203125 0.013395842 1.253662109375 0.01340104 1.253662109375 0.013401042 1.21826171875 0.01340624 1.21826171875 0.013406242 1.18408203125 0.01341146 1.18408203125 0.013411462 1.151123046875 0.01341666 1.151123046875 0.013416662 1.119384765625 0.01342188 1.119384765625 0.013421882 1.0888671875 0.01342708 1.0888671875 0.013427082 1.0595703125 0.0134323 1.0595703125 0.013432302 1.031494140625 0.0134375 1.031494140625 0.013437502 1.005859375 0.0134427 1.005859375 0.013442702 0.980224609375 0.01344792 0.980224609375 0.013447922 0.95703125 0.01345312 0.95703125 0.013453122 0.93505859375 0.01345834 0.93505859375 0.013458342 0.91552734375 0.01346354 0.91552734375 0.013463542 0.89599609375 0.01346876 0.89599609375 0.013468762 0.87890625 0.01347396 0.87890625 0.013473962 0.8642578125 0.01347916 0.8642578125 0.013479162 0.849609375 0.01348438 0.849609375 0.013484382 0.83740234375 0.01348958 0.83740234375 0.013489582 0.82763671875 0.0134948 0.82763671875 0.013494802 0.819091796875 0.0135 0.819091796875 0.013500002 0.811767578125 0.0135052 0.811767578125 0.013505202 0.806884765625 0.01351042 0.806884765625 0.013510422 0.804443359375 0.01351562 0.804443359375 0.013515622 0.80322265625 0.01352604 0.80322265625 0.013526042 0.8056640625 0.01353124 0.8056640625 0.013531242 0.810546875 0.01353646 0.810546875 0.013536462 0.816650390625 0.01354166 0.816650390625 0.013541662 0.823974609375 0.01354688 0.823974609375 0.013546882 0.8349609375 0.01355208 0.8349609375 0.013552082 0.845947265625 0.0135573 0.845947265625 0.013557302 0.860595703125 0.0135625 0.860595703125 0.013562502 0.875244140625 0.0135677 0.875244140625 0.013567702 0.8935546875 0.01357292 0.8935546875 0.013572922 0.9130859375 0.01357812 0.9130859375 0.013578122 0.933837890625 0.01358334 0.933837890625 0.013583342 0.95703125 0.01358854 0.95703125 0.013588542 0.982666015625 0.01359376 0.982666015625 0.013593762 1.009521484375 0.01359896 1.009521484375 0.013598962 1.03759765625 0.01360416 1.03759765625 0.013604162 1.068115234375 0.01360938 1.068115234375 0.013609382 1.099853515625 0.01361458 1.099853515625 0.013614582 1.134033203125 0.0136198 1.134033203125 0.013619802 1.16943359375 0.013625 1.16943359375 0.013625002 1.207275390625 0.0136302 1.207275390625 0.013630202 1.246337890625 0.01363542 1.246337890625 0.013635422 1.28662109375 0.01364062 1.28662109375 0.013640622 1.328125 0.01364584 1.328125 0.013645842 1.3720703125 0.01365104 1.3720703125 0.013651042 1.417236328125 0.01365624 1.417236328125 0.013656242 1.46484375 0.01366146 1.46484375 0.013661462 1.512451171875 0.01366666 1.512451171875 0.013666662 1.5625 0.01367188 1.5625 0.013671882 1.612548828125 0.01367708 1.612548828125 0.013677082 1.6650390625 0.0136823 1.6650390625 0.013682302 1.71875 0.0136875 1.71875 0.013687502 1.7724609375 0.0136927 1.7724609375 0.013692702 1.82861328125 0.01369792 1.82861328125 0.013697922 1.885986328125 0.01370312 1.885986328125 0.013703122 1.943359375 0.01370834 1.943359375 0.013708342 2.001953125 0.01371354 2.001953125 0.013713542 2.061767578125 0.01371876 2.061767578125 0.013718762 2.122802734375 0.01372396 2.122802734375 0.013723962 2.183837890625 0.01372916 2.183837890625 0.013729162 2.244873046875 0.01373438 2.244873046875 0.013734382 2.308349609375 0.01373958 2.308349609375 0.013739582 2.371826171875 0.0137448 2.371826171875 0.013744802 2.435302734375 0.01375 2.435302734375 0.013750002 2.498779296875 0.0137552 2.498779296875 0.013755202 2.5634765625 0.01376042 2.5634765625 0.013760422 2.62939453125 0.01376562 2.62939453125 0.013765622 2.694091796875 0.01377084 2.694091796875 0.013770842 2.760009765625 0.01377604 2.760009765625 0.013776042 2.82470703125 0.01378124 2.82470703125 0.013781242 2.890625 0.01378646 2.890625 0.013786462 2.955322265625 0.01379166 2.955322265625 0.013791662 3.021240234375 0.01379688 3.021240234375 0.013796882 3.0859375 0.01380208 3.0859375 0.013802082 3.150634765625 0.0138073 3.150634765625 0.013807302 3.21533203125 0.0138125 3.21533203125 0.013812502 3.280029296875 0.0138177 3.280029296875 0.013817702 3.343505859375 0.01382292 3.343505859375 0.013822922 3.40576171875 0.01382812 3.40576171875 0.013828122 3.468017578125 0.01383334 3.468017578125 0.013833342 3.5302734375 0.01383854 3.5302734375 0.013838542 3.59130859375 0.01384376 3.59130859375 0.013843762 3.651123046875 0.01384896 3.651123046875 0.013848962 3.7109375 0.01385416 3.7109375 0.013854162 3.768310546875 0.01385938 3.768310546875 0.013859382 3.82568359375 0.01386458 3.82568359375 0.013864582 3.8818359375 0.0138698 3.8818359375 0.013869802 3.936767578125 0.013875 3.936767578125 0.013875002 3.990478515625 0.0138802 3.990478515625 0.013880202 4.04296875 0.01388542 4.04296875 0.013885422 4.09423828125 0.01389062 4.09423828125 0.013890622 4.14306640625 0.01389584 4.14306640625 0.013895842 4.190673828125 0.01390104 4.190673828125 0.013901042 4.237060546875 0.01390624 4.237060546875 0.013906242 4.2822265625 0.01391146 4.2822265625 0.013911462 4.324951171875 0.01391666 4.324951171875 0.013916662 4.366455078125 0.01392188 4.366455078125 0.013921882 4.405517578125 0.01392708 4.405517578125 0.013927082 4.443359375 0.0139323 4.443359375 0.013932302 4.478759765625 0.0139375 4.478759765625 0.013937502 4.512939453125 0.0139427 4.512939453125 0.013942702 4.544677734375 0.01394792 4.544677734375 0.013947922 4.573974609375 0.01395312 4.573974609375 0.013953122 4.60205078125 0.01395834 4.60205078125 0.013958342 4.62646484375 0.01396354 4.62646484375 0.013963542 4.649658203125 0.01396876 4.649658203125 0.013968762 4.671630859375 0.01397396 4.671630859375 0.013973962 4.68994140625 0.01397916 4.68994140625 0.013979162 4.705810546875 0.01398438 4.705810546875 0.013984382 4.720458984375 0.01398958 4.720458984375 0.013989582 4.732666015625 0.0139948 4.732666015625 0.013994802 4.7412109375 0.014 4.7412109375 0.014000002 4.74853515625 0.0140052 4.74853515625 0.014005202 4.747314453125 0.01401042 4.747314453125 0.014010422 4.74365234375 0.01401562 4.74365234375 0.014015622 4.737548828125 0.01402084 4.737548828125 0.014020842 4.72900390625 0.01402604 4.72900390625 0.014026042 4.71923828125 0.01403124 4.71923828125 0.014031242 4.705810546875 0.01403646 4.705810546875 0.014036462 4.68994140625 0.01404166 4.68994140625 0.014041662 4.671630859375 0.01404688 4.671630859375 0.014046882 4.652099609375 0.01405208 4.652099609375 0.014052082 4.62890625 0.0140573 4.62890625 0.014057302 4.6044921875 0.0140625 4.6044921875 0.014062502 4.57763671875 0.0140677 4.57763671875 0.014067702 4.54833984375 0.01407292 4.54833984375 0.014072922 4.5166015625 0.01407812 4.5166015625 0.014078122 4.483642578125 0.01408334 4.483642578125 0.014083342 4.447021484375 0.01408854 4.447021484375 0.014088542 4.4091796875 0.01409376 4.4091796875 0.014093762 4.3701171875 0.01409896 4.3701171875 0.014098962 4.327392578125 0.01410416 4.327392578125 0.014104162 4.283447265625 0.01410938 4.283447265625 0.014109382 4.23828125 0.01411458 4.23828125 0.014114582 4.190673828125 0.0141198 4.190673828125 0.014119802 4.140625 0.014125 4.140625 0.014125002 4.090576171875 0.0141302 4.090576171875 0.014130202 4.036865234375 0.01413542 4.036865234375 0.014135422 3.98193359375 0.01414062 3.98193359375 0.014140622 3.927001953125 0.01414584 3.927001953125 0.014145842 3.868408203125 0.01415104 3.868408203125 0.014151042 3.809814453125 0.01415624 3.809814453125 0.014156242 3.748779296875 0.01416146 3.748779296875 0.014161462 3.687744140625 0.01416666 3.687744140625 0.014166662 3.624267578125 0.01417188 3.624267578125 0.014171882 3.5595703125 0.01417708 3.5595703125 0.014177082 3.494873046875 0.0141823 3.494873046875 0.014182302 3.427734375 0.0141875 3.427734375 0.014187502 3.360595703125 0.0141927 3.360595703125 0.014192702 3.292236328125 0.01419792 3.292236328125 0.014197922 3.22265625 0.01420312 3.22265625 0.014203122 3.15185546875 0.01420834 3.15185546875 0.014208342 3.0810546875 0.01421354 3.0810546875 0.014213542 3.01025390625 0.01421876 3.01025390625 0.014218762 2.938232421875 0.01422396 2.938232421875 0.014223962 2.8662109375 0.01422916 2.8662109375 0.014229162 2.79296875 0.01423438 2.79296875 0.014234382 2.7197265625 0.01423958 2.7197265625 0.014239582 2.646484375 0.0142448 2.646484375 0.014244802 2.5732421875 0.01425 2.5732421875 0.014250002 2.5 0.0142552 2.5 0.014255202 2.425537109375 0.01426042 2.425537109375 0.014260422 2.352294921875 0.01426562 2.352294921875 0.014265622 2.279052734375 0.01427084 2.279052734375 0.014270842 2.205810546875 0.01427604 2.205810546875 0.014276042 2.132568359375 0.01428124 2.132568359375 0.014281242 2.060546875 0.01428646 2.060546875 0.014286462 1.988525390625 0.01429166 1.988525390625 0.014291662 1.917724609375 0.01429688 1.917724609375 0.014296882 1.846923828125 0.01430208 1.846923828125 0.014302082 1.776123046875 0.0143073 1.776123046875 0.014307302 1.70654296875 0.0143125 1.70654296875 0.014312502 1.63818359375 0.0143177 1.63818359375 0.014317702 1.571044921875 0.01432292 1.571044921875 0.014322922 1.50390625 0.01432812 1.50390625 0.014328122 1.439208984375 0.01433334 1.439208984375 0.014333342 1.37451171875 0.01433854 1.37451171875 0.014338542 1.31103515625 0.01434376 1.31103515625 0.014343762 1.25 0.01434896 1.25 0.014348962 1.18896484375 0.01435416 1.18896484375 0.014354162 1.13037109375 0.01435938 1.13037109375 0.014359382 1.07177734375 0.01436458 1.07177734375 0.014364582 1.016845703125 0.0143698 1.016845703125 0.014369802 0.9619140625 0.014375 0.9619140625 0.014375002 0.908203125 0.0143802 0.908203125 0.014380202 0.858154296875 0.01438542 0.858154296875 0.014385422 0.80810546875 0.01439062 0.80810546875 0.014390622 0.760498046875 0.01439584 0.760498046875 0.014395842 0.71533203125 0.01440104 0.71533203125 0.014401042 0.67138671875 0.01440624 0.67138671875 0.014406242 0.628662109375 0.01441146 0.628662109375 0.014411462 0.589599609375 0.01441666 0.589599609375 0.014416662 0.5517578125 0.01442188 0.5517578125 0.014421882 0.51513671875 0.01442708 0.51513671875 0.014427082 0.482177734375 0.0144323 0.482177734375 0.014432302 0.450439453125 0.0144375 0.450439453125 0.014437502 0.421142578125 0.0144427 0.421142578125 0.014442702 0.394287109375 0.01444792 0.394287109375 0.014447922 0.369873046875 0.01445312 0.369873046875 0.014453122 0.3466796875 0.01445834 0.3466796875 0.014458342 0.3271484375 0.01446354 0.3271484375 0.014463542 0.308837890625 0.01446876 0.308837890625 0.014468762 0.29296875 0.01447396 0.29296875 0.014473962 0.279541015625 0.01447916 0.279541015625 0.014479162 0.269775390625 0.01448438 0.269775390625 0.014484382 0.26123046875 0.01448958 0.26123046875 0.014489582 0.255126953125 0.0144948 0.255126953125 0.014494802 0.25146484375 0.0145 0.25146484375 0.014500002 0.250244140625 0.0145052 0.250244140625 0.014505202 0.25146484375 0.01451042 0.25146484375 0.014510422 0.255126953125 0.01451562 0.255126953125 0.014515622 0.26123046875 0.01452084 0.26123046875 0.014520842 0.269775390625 0.01452604 0.269775390625 0.014526042 0.279541015625 0.01453124 0.279541015625 0.014531242 0.29296875 0.01453646 0.29296875 0.014536462 0.308837890625 0.01454166 0.308837890625 0.014541662 0.3271484375 0.01454688 0.3271484375 0.014546882 0.3466796875 0.01455208 0.3466796875 0.014552082 0.369873046875 0.0145573 0.369873046875 0.014557302 0.394287109375 0.0145625 0.394287109375 0.014562502 0.421142578125 0.0145677 0.421142578125 0.014567702 0.450439453125 0.01457292 0.450439453125 0.014572922 0.482177734375 0.01457812 0.482177734375 0.014578122 0.51513671875 0.01458334 0.51513671875 0.014583342 0.5517578125 0.01458854 0.5517578125 0.014588542 0.589599609375 0.01459376 0.589599609375 0.014593762 0.628662109375 0.01459896 0.628662109375 0.014598962 0.67138671875 0.01460416 0.67138671875 0.014604162 0.71533203125 0.01460938 0.71533203125 0.014609382 0.760498046875 0.01461458 0.760498046875 0.014614582 0.80810546875 0.0146198 0.80810546875 0.014619802 0.858154296875 0.014625 0.858154296875 0.014625002 0.908203125 0.0146302 0.908203125 0.014630202 0.9619140625 0.01463542 0.9619140625 0.014635422 1.016845703125 0.01464062 1.016845703125 0.014640622 1.07177734375 0.01464584 1.07177734375 0.014645842 1.13037109375 0.01465104 1.13037109375 0.014651042 1.18896484375 0.01465624 1.18896484375 0.014656242 1.25 0.01466146 1.25 0.014661462 1.31103515625 0.01466666 1.31103515625 0.014666662 1.37451171875 0.01467188 1.37451171875 0.014671882 1.439208984375 0.01467708 1.439208984375 0.014677082 1.50390625 0.0146823 1.50390625 0.014682302 1.571044921875 0.0146875 1.571044921875 0.014687502 1.63818359375 0.0146927 1.63818359375 0.014692702 1.70654296875 0.01469792 1.70654296875 0.014697922 1.776123046875 0.01470312 1.776123046875 0.014703122 1.846923828125 0.01470834 1.846923828125 0.014708342 1.917724609375 0.01471354 1.917724609375 0.014713542 1.988525390625 0.01471876 1.988525390625 0.014718762 2.060546875 0.01472396 2.060546875 0.014723962 2.132568359375 0.01472916 2.132568359375 0.014729162 2.205810546875 0.01473438 2.205810546875 0.014734382 2.279052734375 0.01473958 2.279052734375 0.014739582 2.352294921875 0.0147448 2.352294921875 0.014744802 2.425537109375 0.01475 2.425537109375 0.014750002 2.498779296875 0.0147552 2.498779296875 0.014755202 2.5732421875 0.01476042 2.5732421875 0.014760422 2.646484375 0.01476562 2.646484375 0.014765622 2.7197265625 0.01477084 2.7197265625 0.014770842 2.79296875 0.01477604 2.79296875 0.014776042 2.8662109375 0.01478124 2.8662109375 0.014781242 2.938232421875 0.01478646 2.938232421875 0.014786462 3.01025390625 0.01479166 3.01025390625 0.014791662 3.0810546875 0.01479688 3.0810546875 0.014796882 3.15185546875 0.01480208 3.15185546875 0.014802082 3.22265625 0.0148073 3.22265625 0.014807302 3.292236328125 0.0148125 3.292236328125 0.014812502 3.360595703125 0.0148177 3.360595703125 0.014817702 3.427734375 0.01482292 3.427734375 0.014822922 3.494873046875 0.01482812 3.494873046875 0.014828122 3.5595703125 0.01483334 3.5595703125 0.014833342 3.624267578125 0.01483854 3.624267578125 0.014838542 3.687744140625 0.01484376 3.687744140625 0.014843762 3.748779296875 0.01484896 3.748779296875 0.014848962 3.809814453125 0.01485416 3.809814453125 0.014854162 3.868408203125 0.01485938 3.868408203125 0.014859382 3.927001953125 0.01486458 3.927001953125 0.014864582 3.98193359375 0.0148698 3.98193359375 0.014869802 4.036865234375 0.014875 4.036865234375 0.014875002 4.090576171875 0.0148802 4.090576171875 0.014880202 4.140625 0.01488542 4.140625 0.014885422 4.190673828125 0.01489062 4.190673828125 0.014890622 4.23828125 0.01489584 4.23828125 0.014895842 4.283447265625 0.01490104 4.283447265625 0.014901042 4.327392578125 0.01490624 4.327392578125 0.014906242 4.3701171875 0.01491146 4.3701171875 0.014911462 4.4091796875 0.01491666 4.4091796875 0.014916662 4.447021484375 0.01492188 4.447021484375 0.014921882 4.483642578125 0.01492708 4.483642578125 0.014927082 4.5166015625 0.0149323 4.5166015625 0.014932302 4.54833984375 0.0149375 4.54833984375 0.014937502 4.57763671875 0.0149427 4.57763671875 0.014942702 4.6044921875 0.01494792 4.6044921875 0.014947922 4.62890625 0.01495312 4.62890625 0.014953122 4.652099609375 0.01495834 4.652099609375 0.014958342 4.671630859375 0.01496354 4.671630859375 0.014963542 4.68994140625 0.01496876 4.68994140625 0.014968762 4.705810546875 0.01497396 4.705810546875 0.014973962 4.71923828125 0.01497916 4.71923828125 0.014979162 4.72900390625 0.01498438 4.72900390625 0.014984382 4.737548828125 0.01498958 4.737548828125 0.014989582 4.74365234375 0.0149948 4.74365234375 0.014994802 4.747314453125 0.015 4.747314453125 0.015000002 4.74853515625 0.0150052 4.74853515625 0.015005202 4.747314453125 0.01501042 4.747314453125 0.015010422 4.74365234375 0.01501562 4.74365234375 0.015015622 4.737548828125 0.01502084 4.737548828125 0.015020842 4.72900390625 0.01502604 4.72900390625 0.015026042 4.71923828125 0.01503124 4.71923828125 0.015031242 4.705810546875 0.01503646 4.705810546875 0.015036462 4.68994140625 0.01504166 4.68994140625 0.015041662 4.671630859375 0.01504688 4.671630859375 0.015046882 4.652099609375 0.01505208 4.652099609375 0.015052082 4.62890625 0.0150573 4.62890625 0.015057302 4.6044921875 0.0150625 4.6044921875 0.015062502 4.57763671875 0.0150677 4.57763671875 0.015067702 4.54833984375 0.01507292 4.54833984375 0.015072922 4.5166015625 0.01507812 4.5166015625 0.015078122 4.483642578125 0.01508334 4.483642578125 0.015083342 4.447021484375 0.01508854 4.447021484375 0.015088542 4.4091796875 0.01509376 4.4091796875 0.015093762 4.3701171875 0.01509896 4.3701171875 0.015098962 4.327392578125 0.01510416 4.327392578125 0.015104162 4.283447265625 0.01510938 4.283447265625 0.015109382 4.23828125 0.01511458 4.23828125 0.015114582 4.190673828125 0.0151198 4.190673828125 0.015119802 4.140625 0.015125 4.140625 0.015125002 4.090576171875 0.0151302 4.090576171875 0.015130202 4.036865234375 0.01513542 4.036865234375 0.015135422 3.98193359375 0.01514062 3.98193359375 0.015140622 3.927001953125 0.01514584 3.927001953125 0.015145842 3.868408203125 0.01515104 3.868408203125 0.015151042 3.809814453125 0.01515624 3.809814453125 0.015156242 3.748779296875 0.01516146 3.748779296875 0.015161462 3.687744140625 0.01516666 3.687744140625 0.015166662 3.624267578125 0.01517188 3.624267578125 0.015171882 3.5595703125 0.01517708 3.5595703125 0.015177082 3.494873046875 0.0151823 3.494873046875 0.015182302 3.427734375 0.0151875 3.427734375 0.015187502 3.360595703125 0.0151927 3.360595703125 0.015192702 3.292236328125 0.01519792 3.292236328125 0.015197922 3.22265625 0.01520312 3.22265625 0.015203122 3.15185546875 0.01520834 3.15185546875 0.015208342 3.0810546875 0.01521354 3.0810546875 0.015213542 3.01025390625 0.01521876 3.01025390625 0.015218762 2.938232421875 0.01522396 2.938232421875 0.015223962 2.8662109375 0.01522916 2.8662109375 0.015229162 2.79296875 0.01523438 2.79296875 0.015234382 2.7197265625 0.01523958 2.7197265625 0.015239582 2.646484375 0.0152448 2.646484375 0.015244802 2.5732421875 0.01525 2.5732421875 0.015250002 2.5 0.0152552 2.5 0.015255202 2.425537109375 0.01526042 2.425537109375 0.015260422 2.352294921875 0.01526562 2.352294921875 0.015265622 2.279052734375 0.01527084 2.279052734375 0.015270842 2.205810546875 0.01527604 2.205810546875 0.015276042 2.132568359375 0.01528124 2.132568359375 0.015281242 2.060546875 0.01528646 2.060546875 0.015286462 1.988525390625 0.01529166 1.988525390625 0.015291662 1.917724609375 0.01529688 1.917724609375 0.015296882 1.846923828125 0.01530208 1.846923828125 0.015302082 1.776123046875 0.0153073 1.776123046875 0.015307302 1.70654296875 0.0153125 1.70654296875 0.015312502 1.63818359375 0.0153177 1.63818359375 0.015317702 1.571044921875 0.01532292 1.571044921875 0.015322922 1.50390625 0.01532812 1.50390625 0.015328122 1.439208984375 0.01533334 1.439208984375 0.015333342 1.37451171875 0.01533854 1.37451171875 0.015338542 1.31103515625 0.01534376 1.31103515625 0.015343762 1.25 0.01534896 1.25 0.015348962 1.18896484375 0.01535416 1.18896484375 0.015354162 1.13037109375 0.01535938 1.13037109375 0.015359382 1.07177734375 0.01536458 1.07177734375 0.015364582 1.016845703125 0.0153698 1.016845703125 0.015369802 0.9619140625 0.015375 0.9619140625 0.015375002 0.908203125 0.0153802 0.908203125 0.015380202 0.858154296875 0.01538542 0.858154296875 0.015385422 0.80810546875 0.01539062 0.80810546875 0.015390622 0.760498046875 0.01539584 0.760498046875 0.015395842 0.71533203125 0.01540104 0.71533203125 0.015401042 0.67138671875 0.01540624 0.67138671875 0.015406242 0.628662109375 0.01541146 0.628662109375 0.015411462 0.589599609375 0.01541666 0.589599609375 0.015416662 0.5517578125 0.01542188 0.5517578125 0.015421882 0.51513671875 0.01542708 0.51513671875 0.015427082 0.482177734375 0.0154323 0.482177734375 0.015432302 0.450439453125 0.0154375 0.450439453125 0.015437502 0.421142578125 0.0154427 0.421142578125 0.015442702 0.394287109375 0.01544792 0.394287109375 0.015447922 0.369873046875 0.01545312 0.369873046875 0.015453122 0.3466796875 0.01545834 0.3466796875 0.015458342 0.3271484375 0.01546354 0.3271484375 0.015463542 0.308837890625 0.01546876 0.308837890625 0.015468762 0.29296875 0.01547396 0.29296875 0.015473962 0.279541015625 0.01547916 0.279541015625 0.015479162 0.269775390625 0.01548438 0.269775390625 0.015484382 0.26123046875 0.01548958 0.26123046875 0.015489582 0.255126953125 0.0154948 0.255126953125 0.015494802 0.25146484375 0.0155 0.25146484375 0.015500002 0.250244140625 0.0155052 0.250244140625 0.015505202 0.25146484375 0.01551042 0.25146484375 0.015510422 0.255126953125 0.01551562 0.255126953125 0.015515622 0.26123046875 0.01552084 0.26123046875 0.015520842 0.269775390625 0.01552604 0.269775390625 0.015526042 0.279541015625 0.01553124 0.279541015625 0.015531242 0.29296875 0.01553646 0.29296875 0.015536462 0.308837890625 0.01554166 0.308837890625 0.015541662 0.3271484375 0.01554688 0.3271484375 0.015546882 0.3466796875 0.01555208 0.3466796875 0.015552082 0.369873046875 0.0155573 0.369873046875 0.015557302 0.394287109375 0.0155625 0.394287109375 0.015562502 0.421142578125 0.0155677 0.421142578125 0.015567702 0.450439453125 0.01557292 0.450439453125 0.015572922 0.482177734375 0.01557812 0.482177734375 0.015578122 0.51513671875 0.01558334 0.51513671875 0.015583342 0.5517578125 0.01558854 0.5517578125 0.015588542 0.589599609375 0.01559376 0.589599609375 0.015593762 0.628662109375 0.01559896 0.628662109375 0.015598962 0.67138671875 0.01560416 0.67138671875 0.015604162 0.71533203125 0.01560938 0.71533203125 0.015609382 0.760498046875 0.01561458 0.760498046875 0.015614582 0.80810546875 0.0156198 0.80810546875 0.015619802 0.858154296875 0.015625 0.858154296875 0.015625002 0.908203125 0.0156302 0.908203125 0.015630202 0.9619140625 0.01563542 0.9619140625 0.015635422 1.016845703125 0.01564062 1.016845703125 0.015640622 1.07177734375 0.01564584 1.07177734375 0.015645842 1.13037109375 0.01565104 1.13037109375 0.015651042 1.18896484375 0.01565624 1.18896484375 0.015656242 1.25 0.01566146 1.25 0.015661462 1.31103515625 0.01566666 1.31103515625 0.015666662 1.37451171875 0.01567188 1.37451171875 0.015671882 1.439208984375 0.01567708 1.439208984375 0.015677082 1.50390625 0.0156823 1.50390625 0.015682302 1.571044921875 0.0156875 1.571044921875 0.015687502 1.63818359375 0.0156927 1.63818359375 0.015692702 1.70654296875 0.01569792 1.70654296875 0.015697922 1.776123046875 0.01570312 1.776123046875 0.015703122 1.846923828125 0.01570834 1.846923828125 0.015708342 1.917724609375 0.01571354 1.917724609375 0.015713542 1.988525390625 0.01571876 1.988525390625 0.015718762 2.060546875 0.01572396 2.060546875 0.015723962 2.132568359375 0.01572916 2.132568359375 0.015729162 2.205810546875 0.01573438 2.205810546875 0.015734382 2.279052734375 0.01573958 2.279052734375 0.015739582 2.352294921875 0.0157448 2.352294921875 0.015744802 2.425537109375 0.01575 2.425537109375 0.015750002 2.498779296875 0.0157552 2.498779296875 0.015755202 2.5732421875 0.01576042 2.5732421875 0.015760422 2.646484375 0.01576562 2.646484375 0.015765622 2.7197265625 0.01577084 2.7197265625 0.015770842 2.79296875 0.01577604 2.79296875 0.015776042 2.8662109375 0.01578124 2.8662109375 0.015781242 2.938232421875 0.01578646 2.938232421875 0.015786462 3.01025390625 0.01579166 3.01025390625 0.015791662 3.0810546875 0.01579688 3.0810546875 0.015796882 3.15185546875 0.01580208 3.15185546875 0.015802082 3.22265625 0.0158073 3.22265625 0.015807302 3.292236328125 0.0158125 3.292236328125 0.015812502 3.360595703125 0.0158177 3.360595703125 0.015817702 3.427734375 0.01582292 3.427734375 0.015822922 3.494873046875 0.01582812 3.494873046875 0.015828122 3.5595703125 0.01583334 3.5595703125 0.015833342 3.624267578125 0.01583854 3.624267578125 0.015838542 3.687744140625 0.01584376 3.687744140625 0.015843762 3.748779296875 0.01584896 3.748779296875 0.015848962 3.809814453125 0.01585416 3.809814453125 0.015854162 3.868408203125 0.01585938 3.868408203125 0.015859382 3.927001953125 0.01586458 3.927001953125 0.015864582 3.98193359375 0.0158698 3.98193359375 0.015869802 4.036865234375 0.015875 4.036865234375 0.015875002 4.090576171875 0.0158802 4.090576171875 0.015880202 4.140625 0.01588542 4.140625 0.015885422 4.190673828125 0.01589062 4.190673828125 0.015890622 4.23828125 0.01589584 4.23828125 0.015895842 4.283447265625 0.01590104 4.283447265625 0.015901042 4.327392578125 0.01590624 4.327392578125 0.015906242 4.3701171875 0.01591146 4.3701171875 0.015911462 4.4091796875 0.01591666 4.4091796875 0.015916662 4.447021484375 0.01592188 4.447021484375 0.015921882 4.483642578125 0.01592708 4.483642578125 0.015927082 4.5166015625 0.0159323 4.5166015625 0.015932302 4.54833984375 0.0159375 4.54833984375 0.015937502 4.57763671875 0.0159427 4.57763671875 0.015942702 4.6044921875 0.01594792 4.6044921875 0.015947922 4.62890625 0.01595312 4.62890625 0.015953122 4.652099609375 0.01595834 4.652099609375 0.015958342 4.671630859375 0.01596354 4.671630859375 0.015963542 4.68994140625 0.01596876 4.68994140625 0.015968762 4.705810546875 0.01597396 4.705810546875 0.015973962 4.71923828125 0.01597916 4.71923828125 0.015979162 4.72900390625 0.01598438 4.72900390625 0.015984382 4.737548828125 0.01598958 4.737548828125 0.015989582 4.74365234375 0.0159948 4.74365234375 0.015994802 4.747314453125 0.016 4.747314453125)
Ra srca a 5274.69962770183
Vb srcb 0 PWL(0 2.5 5.2e-06 2.5 5.202e-06 2.493896484375 1.042e-05 2.493896484375 1.0422e-05 2.48779296875 1.562e-05 2.48779296875 1.5622e-05 2.481689453125 2.084e-05 2.481689453125 2.0842e-05 2.4755859375 2.604e-05 2.4755859375 2.6042e-05 2.470703125 3.124e-05 2.470703125 3.1242e-05 2.464599609375 3.646e-05 2.464599609375 3.6462e-05 2.459716796875 4.166e-05 2.459716796875 4.1662e-05 2.45361328125 4.688e-05 2.45361328125 4.6882e-05 2.44873046875 5.208e-05 2.44873046875 5.2082e-05 2.44384765625 5.73e-05 2.44384765625 5.7302e-05 2.43896484375 6.25e-05 2.43896484375 6.2502e-05 2.43408203125 6.77e-05 2.43408203125 6.7702e-05 2.430419921875 7.292e-05 2.430419921875 7.2922e-05 2.425537109375 7.812e-05 2.425537109375 7.8122e-05 2.421875 8.334e-05 2.421875 8.3342e-05 2.418212890625 8.854e-05 2.418212890625 8.8542e-05 2.41455078125 9.376e-05 2.41455078125 9.3762e-05 2.412109375 9.896e-05 2.412109375 9.8962e-05 2.408447265625 0.00010416 2.408447265625 0.000104162 2.406005859375 0.00010938 2.406005859375 0.000109382 2.40478515625 0.00011458 2.40478515625 0.000114582 2.40234375 0.0001198 2.40234375 0.000119802 2.401123046875 0.000125 2.401123046875 0.000125002 2.39990234375 0.0001302 2.39990234375 0.000130202 2.398681640625 0.00014584 2.398681640625 0.000145842 2.39990234375 0.00015624 2.39990234375 0.000156242 2.40234375 0.00016146 2.40234375 0.000161462 2.403564453125 0.00016666 2.403564453125 0.000166662 2.406005859375 0.00017188 2.406005859375 0.000171882 2.408447265625 0.00017708 2.408447265625 0.000177082 2.410888671875 0.0001823 2.410888671875 0.000182302 2.41455078125 0.0001875 2.41455078125 0.000187502 2.418212890625 0.0001927 2.418212890625 0.000192702 2.423095703125 0.00019792 2.423095703125 0.000197922 2.427978515625 0.00020312 2.427978515625 0.000203122 2.432861328125 0.00020834 2.432861328125 0.000208342 2.43896484375 0.00021354 2.43896484375 0.000213542 2.445068359375 0.00021876 2.445068359375 0.000218762 2.451171875 0.00022396 2.451171875 0.000223962 2.45849609375 0.00022916 2.45849609375 0.000229162 2.4658203125 0.00023438 2.4658203125 0.000234382 2.47314453125 0.00023958 2.47314453125 0.000239582 2.481689453125 0.0002448 2.481689453125 0.000244802 2.490234375 0.00025 2.490234375 0.000250002 2.5 0.0002552 2.5 0.000255202 2.508544921875 0.00026042 2.508544921875 0.000260422 2.518310546875 0.00026562 2.518310546875 0.000265622 2.528076171875 0.00027084 2.528076171875 0.000270842 2.5390625 0.00027604 2.5390625 0.000276042 2.550048828125 0.00028124 2.550048828125 0.000281242 2.56103515625 0.00028646 2.56103515625 0.000286462 2.572021484375 0.00029166 2.572021484375 0.000291662 2.584228515625 0.00029688 2.584228515625 0.000296882 2.596435546875 0.00030208 2.596435546875 0.000302082 2.608642578125 0.0003073 2.608642578125 0.000307302 2.620849609375 0.0003125 2.620849609375 0.000312502 2.63427734375 0.0003177 2.63427734375 0.000317702 2.646484375 0.00032292 2.646484375 0.000322922 2.659912109375 0.00032812 2.659912109375 0.000328122 2.67333984375 0.00033334 2.67333984375 0.000333342 2.686767578125 0.00033854 2.686767578125 0.000338542 2.7001953125 0.00034376 2.7001953125 0.000343762 2.713623046875 0.00034896 2.713623046875 0.000348962 2.728271484375 0.00035416 2.728271484375 0.000354162 2.74169921875 0.00035938 2.74169921875 0.000359382 2.75634765625 0.00036458 2.75634765625 0.000364582 2.769775390625 0.0003698 2.769775390625 0.000369802 2.783203125 0.000375 2.783203125 0.000375002 2.7978515625 0.0003802 2.7978515625 0.000380202 2.811279296875 0.00038542 2.811279296875 0.000385422 2.82470703125 0.00039062 2.82470703125 0.000390622 2.83935546875 0.00039584 2.83935546875 0.000395842 2.852783203125 0.00040104 2.852783203125 0.000401042 2.8662109375 0.00040624 2.8662109375 0.000406242 2.879638671875 0.00041146 2.879638671875 0.000411462 2.891845703125 0.00041666 2.891845703125 0.000416662 2.9052734375 0.00042188 2.9052734375 0.000421882 2.91748046875 0.00042708 2.91748046875 0.000427082 2.9296875 0.0004323 2.9296875 0.000432302 2.94189453125 0.0004375 2.94189453125 0.000437502 2.9541015625 0.0004427 2.9541015625 0.000442702 2.965087890625 0.00044792 2.965087890625 0.000447922 2.97607421875 0.00045312 2.97607421875 0.000453122 2.987060546875 0.00045834 2.987060546875 0.000458342 2.996826171875 0.00046354 2.996826171875 0.000463542 3.006591796875 0.00046876 3.006591796875 0.000468762 3.016357421875 0.00047396 3.016357421875 0.000473962 3.02490234375 0.00047916 3.02490234375 0.000479162 3.033447265625 0.00048438 3.033447265625 0.000484382 3.0419921875 0.00048958 3.0419921875 0.000489582 3.04931640625 0.0004948 3.04931640625 0.000494802 3.055419921875 0.0005 3.055419921875 0.000500002 3.0615234375 0.0005052 3.0615234375 0.000505202 3.067626953125 0.00051042 3.067626953125 0.000510422 3.072509765625 0.00051562 3.072509765625 0.000515622 3.076171875 0.00052084 3.076171875 0.000520842 3.079833984375 0.00052604 3.079833984375 0.000526042 3.08349609375 0.00053126 3.08349609375 0.000531262 3.0859375 0.00053646 3.0859375 0.000536462 3.087158203125 0.00054166 3.087158203125 0.000541662 3.08837890625 0.00055208 3.08837890625 0.000552082 3.087158203125 0.0005573 3.087158203125 0.000557302 3.0859375 0.0005625 3.0859375 0.000562502 3.08349609375 0.0005677 3.08349609375 0.000567702 3.0810546875 0.00057292 3.0810546875 0.000572922 3.077392578125 0.00057812 3.077392578125 0.000578122 3.072509765625 0.00058334 3.072509765625 0.000583342 3.067626953125 0.00058854 3.067626953125 0.000588542 3.0615234375 0.00059376 3.0615234375 0.000593762 3.05419921875 0.00059896 3.05419921875 0.000598962 3.046875 0.00060416 3.046875 0.000604162 3.038330078125 0.00060938 3.038330078125 0.000609382 3.02978515625 0.00061458 3.02978515625 0.000614582 3.018798828125 0.0006198 3.018798828125 0.000619802 3.0078125 0.000625 3.0078125 0.000625002 2.996826171875 0.0006302 2.996826171875 0.000630202 2.9833984375 0.00063542 2.9833984375 0.000635422 2.97119140625 0.00064062 2.97119140625 0.000640622 2.95654296875 0.00064584 2.95654296875 0.000645842 2.94189453125 0.00065104 2.94189453125 0.000651042 2.926025390625 0.00065624 2.926025390625 0.000656242 2.908935546875 0.00066146 2.908935546875 0.000661462 2.891845703125 0.00066666 2.891845703125 0.000666662 2.874755859375 0.00067188 2.874755859375 0.000671882 2.855224609375 0.00067708 2.855224609375 0.000677082 2.835693359375 0.0006823 2.835693359375 0.000682302 2.816162109375 0.0006875 2.816162109375 0.000687502 2.79541015625 0.0006927 2.79541015625 0.000692702 2.7734375 0.00069792 2.7734375 0.000697922 2.75146484375 0.00070312 2.75146484375 0.000703122 2.7294921875 0.00070834 2.7294921875 0.000708342 2.705078125 0.00071354 2.705078125 0.000713542 2.681884765625 0.00071876 2.681884765625 0.000718762 2.657470703125 0.00072396 2.657470703125 0.000723962 2.6318359375 0.00072916 2.6318359375 0.000729162 2.606201171875 0.00073438 2.606201171875 0.000734382 2.58056640625 0.00073958 2.58056640625 0.000739582 2.5537109375 0.0007448 2.5537109375 0.000744802 2.52685546875 0.00075 2.52685546875 0.000750002 2.5 0.0007552 2.5 0.000755202 2.471923828125 0.00076042 2.471923828125 0.000760422 2.44384765625 0.00076562 2.44384765625 0.000765622 2.41455078125 0.00077084 2.41455078125 0.000770842 2.386474609375 0.00077604 2.386474609375 0.000776042 2.357177734375 0.00078124 2.357177734375 0.000781242 2.327880859375 0.00078646 2.327880859375 0.000786462 2.298583984375 0.00079166 2.298583984375 0.000791662 2.269287109375 0.00079688 2.269287109375 0.000796882 2.23876953125 0.00080208 2.23876953125 0.000802082 2.20947265625 0.0008073 2.20947265625 0.000807302 2.178955078125 0.0008125 2.178955078125 0.000812502 2.149658203125 0.0008177 2.149658203125 0.000817702 2.120361328125 0.00082292 2.120361328125 0.000822922 2.08984375 0.00082812 2.08984375 0.000828122 2.060546875 0.00083334 2.060546875 0.000833342 2.03125 0.00083854 2.03125 0.000838542 2.001953125 0.00084376 2.001953125 0.000843762 1.97265625 0.00084896 1.97265625 0.000848962 1.943359375 0.00085416 1.943359375 0.000854162 1.9140625 0.00085938 1.9140625 0.000859382 1.885986328125 0.00086458 1.885986328125 0.000864582 1.85791015625 0.0008698 1.85791015625 0.000869802 1.8310546875 0.000875 1.8310546875 0.000875002 1.802978515625 0.0008802 1.802978515625 0.000880202 1.77734375 0.00088542 1.77734375 0.000885422 1.75048828125 0.00089062 1.75048828125 0.000890622 1.724853515625 0.00089584 1.724853515625 0.000895842 1.700439453125 0.00090104 1.700439453125 0.000901042 1.676025390625 0.00090624 1.676025390625 0.000906242 1.651611328125 0.00091146 1.651611328125 0.000911462 1.62841796875 0.00091666 1.62841796875 0.000916662 1.6064453125 0.00092188 1.6064453125 0.000921882 1.58447265625 0.00092708 1.58447265625 0.000927082 1.563720703125 0.0009323 1.563720703125 0.000932302 1.544189453125 0.0009375 1.544189453125 0.000937502 1.524658203125 0.0009427 1.524658203125 0.000942702 1.507568359375 0.00094792 1.507568359375 0.000947922 1.4892578125 0.00095312 1.4892578125 0.000953122 1.473388671875 0.00095834 1.473388671875 0.000958342 1.458740234375 0.00096354 1.458740234375 0.000963542 1.444091796875 0.00096876 1.444091796875 0.000968762 1.4306640625 0.00097396 1.4306640625 0.000973962 1.41845703125 0.00097916 1.41845703125 0.000979162 1.407470703125 0.00098438 1.407470703125 0.000984382 1.397705078125 0.00098958 1.397705078125 0.000989582 1.38916015625 0.0009948 1.38916015625 0.000994802 1.380615234375 0.001 1.380615234375 0.001000002 1.37451171875 0.0010052 1.37451171875 0.001005202 1.36962890625 0.00101042 1.36962890625 0.001010422 1.365966796875 0.00101562 1.365966796875 0.001015622 1.3623046875 0.00102084 1.3623046875 0.001020842 1.361083984375 0.00103124 1.361083984375 0.001031242 1.3623046875 0.00103646 1.3623046875 0.001036462 1.363525390625 0.00104166 1.363525390625 0.001041662 1.3671875 0.00104688 1.3671875 0.001046882 1.3720703125 0.00105208 1.3720703125 0.001052082 1.37939453125 0.0010573 1.37939453125 0.001057302 1.38671875 0.0010625 1.38671875 0.001062502 1.395263671875 0.0010677 1.395263671875 0.001067702 1.405029296875 0.00107292 1.405029296875 0.001072922 1.417236328125 0.00107812 1.417236328125 0.001078122 1.429443359375 0.00108334 1.429443359375 0.001083342 1.444091796875 0.00108854 1.444091796875 0.001088542 1.4599609375 0.00109376 1.4599609375 0.001093762 1.47705078125 0.00109896 1.47705078125 0.001098962 1.494140625 0.00110416 1.494140625 0.001104162 1.513671875 0.00110938 1.513671875 0.001109382 1.534423828125 0.00111458 1.534423828125 0.001114582 1.556396484375 0.0011198 1.556396484375 0.001119802 1.57958984375 0.001125 1.57958984375 0.001125002 1.605224609375 0.0011302 1.605224609375 0.001130202 1.630859375 0.00113542 1.630859375 0.001135422 1.65771484375 0.00114062 1.65771484375 0.001140622 1.685791015625 0.00114584 1.685791015625 0.001145842 1.715087890625 0.00115104 1.715087890625 0.001151042 1.74560546875 0.00115624 1.74560546875 0.001156242 1.77734375 0.00116146 1.77734375 0.001161462 1.80908203125 0.00116666 1.80908203125 0.001166662 1.84326171875 0.00117188 1.84326171875 0.001171882 1.878662109375 0.00117708 1.878662109375 0.001177082 1.9140625 0.0011823 1.9140625 0.001182302 1.95068359375 0.0011875 1.95068359375 0.001187502 1.988525390625 0.0011927 1.988525390625 0.001192702 2.0263671875 0.00119792 2.0263671875 0.001197922 2.066650390625 0.00120312 2.066650390625 0.001203122 2.10693359375 0.00120834 2.10693359375 0.001208342 2.147216796875 0.00121354 2.147216796875 0.001213542 2.18994140625 0.00121876 2.18994140625 0.001218762 2.2314453125 0.00122396 2.2314453125 0.001223962 2.275390625 0.00122916 2.275390625 0.001229162 2.3193359375 0.00123438 2.3193359375 0.001234382 2.36328125 0.00123958 2.36328125 0.001239582 2.408447265625 0.0012448 2.408447265625 0.001244802 2.45361328125 0.00125 2.45361328125 0.001250002 2.498779296875 0.0012552 2.498779296875 0.001255202 2.545166015625 0.00126042 2.545166015625 0.001260422 2.591552734375 0.00126562 2.591552734375 0.001265622 2.63916015625 0.00127084 2.63916015625 0.001270842 2.685546875 0.00127604 2.685546875 0.001276042 2.733154296875 0.00128124 2.733154296875 0.001281242 2.78076171875 0.00128646 2.78076171875 0.001286462 2.828369140625 0.00129166 2.828369140625 0.001291662 2.874755859375 0.00129688 2.874755859375 0.001296882 2.92236328125 0.00130208 2.92236328125 0.001302082 2.969970703125 0.0013073 2.969970703125 0.001307302 3.017578125 0.0013125 3.017578125 0.001312502 3.06396484375 0.0013177 3.06396484375 0.001317702 3.111572265625 0.00132292 3.111572265625 0.001322922 3.157958984375 0.00132812 3.157958984375 0.001328122 3.203125 0.00133334 3.203125 0.001333342 3.24951171875 0.00133854 3.24951171875 0.001338542 3.294677734375 0.00134376 3.294677734375 0.001343762 3.338623046875 0.00134896 3.338623046875 0.001348962 3.382568359375 0.00135416 3.382568359375 0.001354162 3.426513671875 0.00135938 3.426513671875 0.001359382 3.46923828125 0.00136458 3.46923828125 0.001364582 3.5107421875 0.0013698 3.5107421875 0.001369802 3.55224609375 0.001375 3.55224609375 0.001375002 3.592529296875 0.0013802 3.592529296875 0.001380202 3.6328125 0.00138542 3.6328125 0.001385422 3.670654296875 0.00139062 3.670654296875 0.001390622 3.70849609375 0.00139584 3.70849609375 0.001395842 3.7451171875 0.00140104 3.7451171875 0.001401042 3.780517578125 0.00140624 3.780517578125 0.001406242 3.814697265625 0.00141146 3.814697265625 0.001411462 3.84765625 0.00141666 3.84765625 0.001416662 3.87939453125 0.00142188 3.87939453125 0.001421882 3.909912109375 0.00142708 3.909912109375 0.001427082 3.939208984375 0.0014323 3.939208984375 0.001432302 3.96728515625 0.0014375 3.96728515625 0.001437502 3.992919921875 0.0014427 3.992919921875 0.001442702 4.0185546875 0.00144792 4.0185546875 0.001447922 4.041748046875 0.00145312 4.041748046875 0.001453122 4.063720703125 0.00145834 4.063720703125 0.001458342 4.083251953125 0.00146354 4.083251953125 0.001463542 4.102783203125 0.00146876 4.102783203125 0.001468762 4.119873046875 0.00147396 4.119873046875 0.001473962 4.134521484375 0.00147916 4.134521484375 0.001479162 4.149169921875 0.00148438 4.149169921875 0.001484382 4.161376953125 0.00148958 4.161376953125 0.001489582 4.171142578125 0.0014948 4.171142578125 0.001494802 4.1796875 0.0015 4.1796875 0.001500002 4.18701171875 0.0015052 4.18701171875 0.001505202 4.19189453125 0.00151042 4.19189453125 0.001510422 4.1943359375 0.00151562 4.1943359375 0.001515622 4.195556640625 0.00152604 4.195556640625 0.001526042 4.193115234375 0.00153124 4.193115234375 0.001531242 4.188232421875 0.00153646 4.188232421875 0.001536462 4.18212890625 0.00154166 4.18212890625 0.001541662 4.1748046875 0.00154688 4.1748046875 0.001546882 4.163818359375 0.00155208 4.163818359375 0.001552082 4.15283203125 0.0015573 4.15283203125 0.001557302 4.13818359375 0.0015625 4.13818359375 0.001562502 4.12353515625 0.0015677 4.12353515625 0.001567702 4.105224609375 0.00157292 4.105224609375 0.001572922 4.085693359375 0.00157812 4.085693359375 0.001578122 4.06494140625 0.00158334 4.06494140625 0.001583342 4.041748046875 0.00158854 4.041748046875 0.001588542 4.01611328125 0.00159376 4.01611328125 0.001593762 3.9892578125 0.00159896 3.9892578125 0.001598962 3.961181640625 0.00160416 3.961181640625 0.001604162 3.9306640625 0.00160938 3.9306640625 0.001609382 3.89892578125 0.00161458 3.89892578125 0.001614582 3.86474609375 0.0016198 3.86474609375 0.001619802 3.829345703125 0.001625 3.829345703125 0.001625002 3.79150390625 0.0016302 3.79150390625 0.001630202 3.75244140625 0.00163542 3.75244140625 0.001635422 3.712158203125 0.00164062 3.712158203125 0.001640622 3.670654296875 0.00164584 3.670654296875 0.001645842 3.626708984375 0.00165104 3.626708984375 0.001651042 3.58154296875 0.00165624 3.58154296875 0.001656242 3.533935546875 0.00166146 3.533935546875 0.001661462 3.486328125 0.00166666 3.486328125 0.001666662 3.436279296875 0.00167188 3.436279296875 0.001671882 3.38623046875 0.00167708 3.38623046875 0.001677082 3.333740234375 0.0016823 3.333740234375 0.001682302 3.280029296875 0.0016875 3.280029296875 0.001687502 3.226318359375 0.0016927 3.226318359375 0.001692702 3.170166015625 0.00169792 3.170166015625 0.001697922 3.11279296875 0.00170312 3.11279296875 0.001703122 3.055419921875 0.00170834 3.055419921875 0.001708342 2.996826171875 0.00171354 2.996826171875 0.001713542 2.93701171875 0.00171876 2.93701171875 0.001718762 2.8759765625 0.00172396 2.8759765625 0.001723962 2.81494140625 0.00172916 2.81494140625 0.001729162 2.75390625 0.00173438 2.75390625 0.001734382 2.6904296875 0.00173958 2.6904296875 0.001739582 2.626953125 0.0017448 2.626953125 0.001744802 2.5634765625 0.00175 2.5634765625 0.001750002 2.5 0.0017552 2.5 0.001755202 2.435302734375 0.00176042 2.435302734375 0.001760422 2.369384765625 0.00176562 2.369384765625 0.001765622 2.3046875 0.00177084 2.3046875 0.001770842 2.23876953125 0.00177604 2.23876953125 0.001776042 2.174072265625 0.00178124 2.174072265625 0.001781242 2.108154296875 0.00178646 2.108154296875 0.001786462 2.04345703125 0.00179166 2.04345703125 0.001791662 1.9775390625 0.00179688 1.9775390625 0.001796882 1.912841796875 0.00180208 1.912841796875 0.001802082 1.84814453125 0.0018073 1.84814453125 0.001807302 1.783447265625 0.0018125 1.783447265625 0.001812502 1.71875 0.0018177 1.71875 0.001817702 1.6552734375 0.00182292 1.6552734375 0.001822922 1.593017578125 0.00182812 1.593017578125 0.001828122 1.53076171875 0.00183334 1.53076171875 0.001833342 1.468505859375 0.00183854 1.468505859375 0.001838542 1.407470703125 0.00184376 1.407470703125 0.001843762 1.34765625 0.00184896 1.34765625 0.001848962 1.287841796875 0.00185416 1.287841796875 0.001854162 1.23046875 0.00185938 1.23046875 0.001859382 1.173095703125 0.00186458 1.173095703125 0.001864582 1.116943359375 0.0018698 1.116943359375 0.001869802 1.06201171875 0.001875 1.06201171875 0.001875002 1.00830078125 0.0018802 1.00830078125 0.001880202 0.955810546875 0.00188542 0.955810546875 0.001885422 0.904541015625 0.00189062 0.904541015625 0.001890622 0.855712890625 0.00189584 0.855712890625 0.001895842 0.80810546875 0.00190104 0.80810546875 0.001901042 0.76171875 0.00190624 0.76171875 0.001906242 0.716552734375 0.00191146 0.716552734375 0.001911462 0.673828125 0.00191666 0.673828125 0.001916662 0.63232421875 0.00192188 0.63232421875 0.001921882 0.59326171875 0.00192708 0.59326171875 0.001927082 0.555419921875 0.0019323 0.555419921875 0.001932302 0.52001953125 0.0019375 0.52001953125 0.001937502 0.48583984375 0.0019427 0.48583984375 0.001942702 0.4541015625 0.00194792 0.4541015625 0.001947922 0.4248046875 0.00195312 0.4248046875 0.001953122 0.396728515625 0.00195834 0.396728515625 0.001958342 0.372314453125 0.00196354 0.372314453125 0.001963542 0.34912109375 0.00196876 0.34912109375 0.001968762 0.3271484375 0.00197396 0.3271484375 0.001973962 0.308837890625 0.00197916 0.308837890625 0.001979162 0.29296875 0.00198438 0.29296875 0.001984382 0.2783203125 0.00198958 0.2783203125 0.001989582 0.26611328125 0.0019948 0.26611328125 0.001994802 0.257568359375 0.002 0.257568359375 0.002000002 0.250244140625 0.0020052 0.250244140625 0.002005202 0.25146484375 0.00201042 0.25146484375 0.002010422 0.255126953125 0.00201562 0.255126953125 0.002015622 0.26123046875 0.00202084 0.26123046875 0.002020842 0.269775390625 0.00202604 0.269775390625 0.002026042 0.279541015625 0.00203124 0.279541015625 0.002031242 0.29296875 0.00203646 0.29296875 0.002036462 0.308837890625 0.00204166 0.308837890625 0.002041662 0.3271484375 0.00204688 0.3271484375 0.002046882 0.3466796875 0.00205208 0.3466796875 0.002052082 0.369873046875 0.0020573 0.369873046875 0.002057302 0.394287109375 0.0020625 0.394287109375 0.002062502 0.421142578125 0.0020677 0.421142578125 0.002067702 0.450439453125 0.00207292 0.450439453125 0.002072922 0.482177734375 0.00207812 0.482177734375 0.002078122 0.51513671875 0.00208334 0.51513671875 0.002083342 0.5517578125 0.00208854 0.5517578125 0.002088542 0.589599609375 0.00209376 0.589599609375 0.002093762 0.628662109375 0.00209896 0.628662109375 0.002098962 0.67138671875 0.00210416 0.67138671875 0.002104162 0.71533203125 0.00210938 0.71533203125 0.002109382 0.760498046875 0.00211458 0.760498046875 0.002114582 0.80810546875 0.0021198 0.80810546875 0.002119802 0.858154296875 0.002125 0.858154296875 0.002125002 0.908203125 0.0021302 0.908203125 0.002130202 0.9619140625 0.00213542 0.9619140625 0.002135422 1.016845703125 0.00214062 1.016845703125 0.002140622 1.07177734375 0.00214584 1.07177734375 0.002145842 1.13037109375 0.00215104 1.13037109375 0.002151042 1.18896484375 0.00215626 1.18896484375 0.002156262 1.25 0.00216146 1.25 0.002161462 1.31103515625 0.00216666 1.31103515625 0.002166662 1.37451171875 0.00217188 1.37451171875 0.002171882 1.439208984375 0.00217708 1.439208984375 0.002177082 1.50390625 0.0021823 1.50390625 0.002182302 1.571044921875 0.0021875 1.571044921875 0.002187502 1.63818359375 0.0021927 1.63818359375 0.002192702 1.70654296875 0.00219792 1.70654296875 0.002197922 1.776123046875 0.00220312 1.776123046875 0.002203122 1.846923828125 0.00220834 1.846923828125 0.002208342 1.917724609375 0.00221354 1.917724609375 0.002213542 1.988525390625 0.00221874 1.988525390625 0.002218742 2.060546875 0.00222396 2.060546875 0.002223962 2.132568359375 0.00222916 2.132568359375 0.002229162 2.205810546875 0.00223438 2.205810546875 0.002234382 2.279052734375 0.00223958 2.279052734375 0.002239582 2.352294921875 0.0022448 2.352294921875 0.002244802 2.425537109375 0.00225 2.425537109375 0.002250002 2.498779296875 0.0022552 2.498779296875 0.002255202 2.5732421875 0.00226042 2.5732421875 0.002260422 2.646484375 0.00226562 2.646484375 0.002265622 2.7197265625 0.00227084 2.7197265625 0.002270842 2.79296875 0.00227604 2.79296875 0.002276042 2.8662109375 0.00228124 2.8662109375 0.002281242 2.938232421875 0.00228646 2.938232421875 0.002286462 3.01025390625 0.00229166 3.01025390625 0.002291662 3.0810546875 0.00229688 3.0810546875 0.002296882 3.15185546875 0.00230208 3.15185546875 0.002302082 3.22265625 0.0023073 3.22265625 0.002307302 3.292236328125 0.0023125 3.292236328125 0.002312502 3.360595703125 0.0023177 3.360595703125 0.002317702 3.427734375 0.00232292 3.427734375 0.002322922 3.494873046875 0.00232812 3.494873046875 0.002328122 3.5595703125 0.00233334 3.5595703125 0.002333342 3.624267578125 0.00233854 3.624267578125 0.002338542 3.687744140625 0.00234376 3.687744140625 0.002343762 3.748779296875 0.00234896 3.748779296875 0.002348962 3.809814453125 0.00235416 3.809814453125 0.002354162 3.868408203125 0.00235938 3.868408203125 0.002359382 3.927001953125 0.00236458 3.927001953125 0.002364582 3.98193359375 0.0023698 3.98193359375 0.002369802 4.036865234375 0.002375 4.036865234375 0.002375002 4.090576171875 0.0023802 4.090576171875 0.002380202 4.140625 0.00238542 4.140625 0.002385422 4.190673828125 0.00239062 4.190673828125 0.002390622 4.23828125 0.00239584 4.23828125 0.002395842 4.283447265625 0.00240104 4.283447265625 0.002401042 4.327392578125 0.00240624 4.327392578125 0.002406242 4.3701171875 0.00241146 4.3701171875 0.002411462 4.4091796875 0.00241666 4.4091796875 0.002416662 4.447021484375 0.00242188 4.447021484375 0.002421882 4.483642578125 0.00242708 4.483642578125 0.002427082 4.5166015625 0.0024323 4.5166015625 0.002432302 4.54833984375 0.0024375 4.54833984375 0.002437502 4.57763671875 0.0024427 4.57763671875 0.002442702 4.6044921875 0.00244792 4.6044921875 0.002447922 4.62890625 0.00245312 4.62890625 0.002453122 4.652099609375 0.00245834 4.652099609375 0.002458342 4.671630859375 0.00246354 4.671630859375 0.002463542 4.68994140625 0.00246876 4.68994140625 0.002468762 4.705810546875 0.00247396 4.705810546875 0.002473962 4.71923828125 0.00247916 4.71923828125 0.002479162 4.72900390625 0.00248438 4.72900390625 0.002484382 4.737548828125 0.00248958 4.737548828125 0.002489582 4.74365234375 0.0024948 4.74365234375 0.002494802 4.747314453125 0.0025 4.747314453125 0.002500002 4.74853515625 0.0025052 4.74853515625 0.002505202 4.747314453125 0.00251042 4.747314453125 0.002510422 4.74365234375 0.00251562 4.74365234375 0.002515622 4.737548828125 0.00252084 4.737548828125 0.002520842 4.72900390625 0.00252604 4.72900390625 0.002526042 4.71923828125 0.00253124 4.71923828125 0.002531242 4.705810546875 0.00253646 4.705810546875 0.002536462 4.68994140625 0.00254166 4.68994140625 0.002541662 4.671630859375 0.00254688 4.671630859375 0.002546882 4.652099609375 0.00255208 4.652099609375 0.002552082 4.62890625 0.0025573 4.62890625 0.002557302 4.6044921875 0.0025625 4.6044921875 0.002562502 4.57763671875 0.0025677 4.57763671875 0.002567702 4.54833984375 0.00257292 4.54833984375 0.002572922 4.5166015625 0.00257812 4.5166015625 0.002578122 4.483642578125 0.00258334 4.483642578125 0.002583342 4.447021484375 0.00258854 4.447021484375 0.002588542 4.4091796875 0.00259376 4.4091796875 0.002593762 4.3701171875 0.00259896 4.3701171875 0.002598962 4.327392578125 0.00260416 4.327392578125 0.002604162 4.283447265625 0.00260938 4.283447265625 0.002609382 4.23828125 0.00261458 4.23828125 0.002614582 4.190673828125 0.0026198 4.190673828125 0.002619802 4.140625 0.002625 4.140625 0.002625002 4.090576171875 0.0026302 4.090576171875 0.002630202 4.036865234375 0.00263542 4.036865234375 0.002635422 3.98193359375 0.00264062 3.98193359375 0.002640622 3.927001953125 0.00264584 3.927001953125 0.002645842 3.868408203125 0.00265104 3.868408203125 0.002651042 3.809814453125 0.00265624 3.809814453125 0.002656242 3.748779296875 0.00266146 3.748779296875 0.002661462 3.687744140625 0.00266666 3.687744140625 0.002666662 3.624267578125 0.00267188 3.624267578125 0.002671882 3.5595703125 0.00267708 3.5595703125 0.002677082 3.494873046875 0.0026823 3.494873046875 0.002682302 3.427734375 0.0026875 3.427734375 0.002687502 3.360595703125 0.0026927 3.360595703125 0.002692702 3.292236328125 0.00269792 3.292236328125 0.002697922 3.22265625 0.00270312 3.22265625 0.002703122 3.15185546875 0.00270834 3.15185546875 0.002708342 3.0810546875 0.00271354 3.0810546875 0.002713542 3.01025390625 0.00271876 3.01025390625 0.002718762 2.938232421875 0.00272396 2.938232421875 0.002723962 2.8662109375 0.00272916 2.8662109375 0.002729162 2.79296875 0.00273438 2.79296875 0.002734382 2.7197265625 0.00273958 2.7197265625 0.002739582 2.646484375 0.0027448 2.646484375 0.002744802 2.5732421875 0.00275 2.5732421875 0.002750002 2.5 0.0027552 2.5 0.002755202 2.425537109375 0.00276042 2.425537109375 0.002760422 2.352294921875 0.00276562 2.352294921875 0.002765622 2.279052734375 0.00277084 2.279052734375 0.002770842 2.205810546875 0.00277604 2.205810546875 0.002776042 2.132568359375 0.00278124 2.132568359375 0.002781242 2.060546875 0.00278646 2.060546875 0.002786462 1.988525390625 0.00279166 1.988525390625 0.002791662 1.917724609375 0.00279688 1.917724609375 0.002796882 1.846923828125 0.00280208 1.846923828125 0.002802082 1.776123046875 0.0028073 1.776123046875 0.002807302 1.70654296875 0.0028125 1.70654296875 0.002812502 1.63818359375 0.0028177 1.63818359375 0.002817702 1.571044921875 0.00282292 1.571044921875 0.002822922 1.50390625 0.00282812 1.50390625 0.002828122 1.439208984375 0.00283334 1.439208984375 0.002833342 1.37451171875 0.00283854 1.37451171875 0.002838542 1.31103515625 0.00284376 1.31103515625 0.002843762 1.25 0.00284896 1.25 0.002848962 1.18896484375 0.00285416 1.18896484375 0.002854162 1.13037109375 0.00285938 1.13037109375 0.002859382 1.07177734375 0.00286458 1.07177734375 0.002864582 1.016845703125 0.0028698 1.016845703125 0.002869802 0.9619140625 0.002875 0.9619140625 0.002875002 0.908203125 0.0028802 0.908203125 0.002880202 0.858154296875 0.00288542 0.858154296875 0.002885422 0.80810546875 0.00289062 0.80810546875 0.002890622 0.760498046875 0.00289584 0.760498046875 0.002895842 0.71533203125 0.00290104 0.71533203125 0.002901042 0.67138671875 0.00290624 0.67138671875 0.002906242 0.628662109375 0.00291146 0.628662109375 0.002911462 0.589599609375 0.00291666 0.589599609375 0.002916662 0.5517578125 0.00292188 0.5517578125 0.002921882 0.51513671875 0.00292708 0.51513671875 0.002927082 0.482177734375 0.0029323 0.482177734375 0.002932302 0.450439453125 0.0029375 0.450439453125 0.002937502 0.421142578125 0.0029427 0.421142578125 0.002942702 0.394287109375 0.00294792 0.394287109375 0.002947922 0.369873046875 0.00295312 0.369873046875 0.002953122 0.3466796875 0.00295834 0.3466796875 0.002958342 0.3271484375 0.00296354 0.3271484375 0.002963542 0.308837890625 0.00296876 0.308837890625 0.002968762 0.29296875 0.00297396 0.29296875 0.002973962 0.279541015625 0.00297916 0.279541015625 0.002979162 0.269775390625 0.00298438 0.269775390625 0.002984382 0.26123046875 0.00298958 0.26123046875 0.002989582 0.255126953125 0.0029948 0.255126953125 0.002994802 0.25146484375 0.003 0.25146484375 0.003000002 0.250244140625 0.0030052 0.250244140625 0.003005202 0.25146484375 0.00301042 0.25146484375 0.003010422 0.255126953125 0.00301562 0.255126953125 0.003015622 0.26123046875 0.00302084 0.26123046875 0.003020842 0.269775390625 0.00302604 0.269775390625 0.003026042 0.279541015625 0.00303124 0.279541015625 0.003031242 0.29296875 0.00303646 0.29296875 0.003036462 0.308837890625 0.00304166 0.308837890625 0.003041662 0.3271484375 0.00304688 0.3271484375 0.003046882 0.3466796875 0.00305208 0.3466796875 0.003052082 0.369873046875 0.0030573 0.369873046875 0.003057302 0.394287109375 0.0030625 0.394287109375 0.003062502 0.421142578125 0.0030677 0.421142578125 0.003067702 0.450439453125 0.00307292 0.450439453125 0.003072922 0.482177734375 0.00307812 0.482177734375 0.003078122 0.51513671875 0.00308334 0.51513671875 0.003083342 0.5517578125 0.00308854 0.5517578125 0.003088542 0.589599609375 0.00309376 0.589599609375 0.003093762 0.628662109375 0.00309896 0.628662109375 0.003098962 0.67138671875 0.00310416 0.67138671875 0.003104162 0.71533203125 0.00310938 0.71533203125 0.003109382 0.760498046875 0.00311458 0.760498046875 0.003114582 0.80810546875 0.0031198 0.80810546875 0.003119802 0.858154296875 0.003125 0.858154296875 0.003125002 0.908203125 0.0031302 0.908203125 0.003130202 0.9619140625 0.00313542 0.9619140625 0.003135422 1.016845703125 0.00314062 1.016845703125 0.003140622 1.07177734375 0.00314584 1.07177734375 0.003145842 1.13037109375 0.00315104 1.13037109375 0.003151042 1.18896484375 0.00315624 1.18896484375 0.003156242 1.25 0.00316146 1.25 0.003161462 1.31103515625 0.00316666 1.31103515625 0.003166662 1.37451171875 0.00317188 1.37451171875 0.003171882 1.439208984375 0.00317708 1.439208984375 0.003177082 1.50390625 0.0031823 1.50390625 0.003182302 1.571044921875 0.0031875 1.571044921875 0.003187502 1.63818359375 0.0031927 1.63818359375 0.003192702 1.70654296875 0.00319792 1.70654296875 0.003197922 1.776123046875 0.00320312 1.776123046875 0.003203122 1.846923828125 0.00320834 1.846923828125 0.003208342 1.917724609375 0.00321354 1.917724609375 0.003213542 1.988525390625 0.00321876 1.988525390625 0.003218762 2.060546875 0.00322396 2.060546875 0.003223962 2.132568359375 0.00322916 2.132568359375 0.003229162 2.205810546875 0.00323438 2.205810546875 0.003234382 2.279052734375 0.00323958 2.279052734375 0.003239582 2.352294921875 0.0032448 2.352294921875 0.003244802 2.425537109375 0.00325 2.425537109375 0.003250002 2.498779296875 0.0032552 2.498779296875 0.003255202 2.5732421875 0.00326042 2.5732421875 0.003260422 2.646484375 0.00326562 2.646484375 0.003265622 2.7197265625 0.00327084 2.7197265625 0.003270842 2.79296875 0.00327604 2.79296875 0.003276042 2.8662109375 0.00328124 2.8662109375 0.003281242 2.938232421875 0.00328646 2.938232421875 0.003286462 3.01025390625 0.00329166 3.01025390625 0.003291662 3.0810546875 0.00329688 3.0810546875 0.003296882 3.15185546875 0.00330208 3.15185546875 0.003302082 3.22265625 0.0033073 3.22265625 0.003307302 3.292236328125 0.0033125 3.292236328125 0.003312502 3.360595703125 0.0033177 3.360595703125 0.003317702 3.427734375 0.00332292 3.427734375 0.003322922 3.494873046875 0.00332812 3.494873046875 0.003328122 3.5595703125 0.00333334 3.5595703125 0.003333342 3.624267578125 0.00333854 3.624267578125 0.003338542 3.687744140625 0.00334376 3.687744140625 0.003343762 3.748779296875 0.00334896 3.748779296875 0.003348962 3.809814453125 0.00335416 3.809814453125 0.003354162 3.868408203125 0.00335938 3.868408203125 0.003359382 3.927001953125 0.00336458 3.927001953125 0.003364582 3.98193359375 0.0033698 3.98193359375 0.003369802 4.036865234375 0.003375 4.036865234375 0.003375002 4.090576171875 0.0033802 4.090576171875 0.003380202 4.140625 0.00338542 4.140625 0.003385422 4.190673828125 0.00339062 4.190673828125 0.003390622 4.23828125 0.00339584 4.23828125 0.003395842 4.283447265625 0.00340104 4.283447265625 0.003401042 4.327392578125 0.00340624 4.327392578125 0.003406242 4.3701171875 0.00341146 4.3701171875 0.003411462 4.4091796875 0.00341666 4.4091796875 0.003416662 4.447021484375 0.00342188 4.447021484375 0.003421882 4.483642578125 0.00342708 4.483642578125 0.003427082 4.5166015625 0.0034323 4.5166015625 0.003432302 4.54833984375 0.0034375 4.54833984375 0.003437502 4.57763671875 0.0034427 4.57763671875 0.003442702 4.6044921875 0.00344792 4.6044921875 0.003447922 4.62890625 0.00345312 4.62890625 0.003453122 4.652099609375 0.00345834 4.652099609375 0.003458342 4.671630859375 0.00346354 4.671630859375 0.003463542 4.68994140625 0.00346876 4.68994140625 0.003468762 4.705810546875 0.00347396 4.705810546875 0.003473962 4.71923828125 0.00347916 4.71923828125 0.003479162 4.72900390625 0.00348438 4.72900390625 0.003484382 4.737548828125 0.00348958 4.737548828125 0.003489582 4.74365234375 0.0034948 4.74365234375 0.003494802 4.747314453125 0.0035 4.747314453125 0.003500002 4.74853515625 0.0035052 4.74853515625 0.003505202 4.747314453125 0.00351042 4.747314453125 0.003510422 4.74365234375 0.00351562 4.74365234375 0.003515622 4.737548828125 0.00352084 4.737548828125 0.003520842 4.72900390625 0.00352604 4.72900390625 0.003526042 4.71923828125 0.00353124 4.71923828125 0.003531242 4.705810546875 0.00353646 4.705810546875 0.003536462 4.68994140625 0.00354166 4.68994140625 0.003541662 4.671630859375 0.00354688 4.671630859375 0.003546882 4.652099609375 0.00355208 4.652099609375 0.003552082 4.62890625 0.0035573 4.62890625 0.003557302 4.6044921875 0.0035625 4.6044921875 0.003562502 4.57763671875 0.0035677 4.57763671875 0.003567702 4.54833984375 0.00357292 4.54833984375 0.003572922 4.5166015625 0.00357812 4.5166015625 0.003578122 4.483642578125 0.00358334 4.483642578125 0.003583342 4.447021484375 0.00358854 4.447021484375 0.003588542 4.4091796875 0.00359376 4.4091796875 0.003593762 4.3701171875 0.00359896 4.3701171875 0.003598962 4.327392578125 0.00360416 4.327392578125 0.003604162 4.283447265625 0.00360938 4.283447265625 0.003609382 4.23828125 0.00361458 4.23828125 0.003614582 4.190673828125 0.0036198 4.190673828125 0.003619802 4.140625 0.003625 4.140625 0.003625002 4.090576171875 0.0036302 4.090576171875 0.003630202 4.036865234375 0.00363542 4.036865234375 0.003635422 3.98193359375 0.00364062 3.98193359375 0.003640622 3.927001953125 0.00364584 3.927001953125 0.003645842 3.868408203125 0.00365104 3.868408203125 0.003651042 3.809814453125 0.00365624 3.809814453125 0.003656242 3.748779296875 0.00366146 3.748779296875 0.003661462 3.687744140625 0.00366666 3.687744140625 0.003666662 3.624267578125 0.00367188 3.624267578125 0.003671882 3.5595703125 0.00367708 3.5595703125 0.003677082 3.494873046875 0.0036823 3.494873046875 0.003682302 3.427734375 0.0036875 3.427734375 0.003687502 3.360595703125 0.0036927 3.360595703125 0.003692702 3.292236328125 0.00369792 3.292236328125 0.003697922 3.22265625 0.00370312 3.22265625 0.003703122 3.15185546875 0.00370834 3.15185546875 0.003708342 3.0810546875 0.00371354 3.0810546875 0.003713542 3.01025390625 0.00371876 3.01025390625 0.003718762 2.938232421875 0.00372396 2.938232421875 0.003723962 2.8662109375 0.00372916 2.8662109375 0.003729162 2.79296875 0.00373438 2.79296875 0.003734382 2.7197265625 0.00373958 2.7197265625 0.003739582 2.646484375 0.0037448 2.646484375 0.003744802 2.5732421875 0.00375 2.5732421875 0.003750002 2.5 0.0037552 2.5 0.003755202 2.425537109375 0.00376042 2.425537109375 0.003760422 2.352294921875 0.00376562 2.352294921875 0.003765622 2.279052734375 0.00377084 2.279052734375 0.003770842 2.205810546875 0.00377604 2.205810546875 0.003776042 2.132568359375 0.00378124 2.132568359375 0.003781242 2.060546875 0.00378646 2.060546875 0.003786462 1.988525390625 0.00379166 1.988525390625 0.003791662 1.917724609375 0.00379688 1.917724609375 0.003796882 1.846923828125 0.00380208 1.846923828125 0.003802082 1.776123046875 0.0038073 1.776123046875 0.003807302 1.70654296875 0.0038125 1.70654296875 0.003812502 1.63818359375 0.0038177 1.63818359375 0.003817702 1.571044921875 0.00382292 1.571044921875 0.003822922 1.50390625 0.00382812 1.50390625 0.003828122 1.439208984375 0.00383334 1.439208984375 0.003833342 1.37451171875 0.00383854 1.37451171875 0.003838542 1.31103515625 0.00384376 1.31103515625 0.003843762 1.25 0.00384896 1.25 0.003848962 1.18896484375 0.00385416 1.18896484375 0.003854162 1.13037109375 0.00385938 1.13037109375 0.003859382 1.07177734375 0.00386458 1.07177734375 0.003864582 1.016845703125 0.0038698 1.016845703125 0.003869802 0.9619140625 0.003875 0.9619140625 0.003875002 0.908203125 0.0038802 0.908203125 0.003880202 0.858154296875 0.00388542 0.858154296875 0.003885422 0.80810546875 0.00389062 0.80810546875 0.003890622 0.760498046875 0.00389584 0.760498046875 0.003895842 0.71533203125 0.00390104 0.71533203125 0.003901042 0.67138671875 0.00390624 0.67138671875 0.003906242 0.628662109375 0.00391146 0.628662109375 0.003911462 0.589599609375 0.00391666 0.589599609375 0.003916662 0.5517578125 0.00392188 0.5517578125 0.003921882 0.51513671875 0.00392708 0.51513671875 0.003927082 0.482177734375 0.0039323 0.482177734375 0.003932302 0.450439453125 0.0039375 0.450439453125 0.003937502 0.421142578125 0.0039427 0.421142578125 0.003942702 0.394287109375 0.00394792 0.394287109375 0.003947922 0.369873046875 0.00395312 0.369873046875 0.003953122 0.3466796875 0.00395834 0.3466796875 0.003958342 0.3271484375 0.00396354 0.3271484375 0.003963542 0.308837890625 0.00396876 0.308837890625 0.003968762 0.29296875 0.00397396 0.29296875 0.003973962 0.279541015625 0.00397916 0.279541015625 0.003979162 0.269775390625 0.00398438 0.269775390625 0.003984382 0.26123046875 0.00398958 0.26123046875 0.003989582 0.255126953125 0.0039948 0.255126953125 0.003994802 0.25146484375 0.004 0.25146484375 0.004000002 0.250244140625 0.0040052 0.250244140625 0.004005202 0.257568359375 0.00401042 0.257568359375 0.004010422 0.26611328125 0.00401562 0.26611328125 0.004015622 0.2783203125 0.00402084 0.2783203125 0.004020842 0.29296875 0.00402604 0.29296875 0.004026042 0.308837890625 0.00403124 0.308837890625 0.004031242 0.3271484375 0.00403646 0.3271484375 0.004036462 0.34912109375 0.00404166 0.34912109375 0.004041662 0.372314453125 0.00404688 0.372314453125 0.004046882 0.396728515625 0.00405208 0.396728515625 0.004052082 0.4248046875 0.0040573 0.4248046875 0.004057302 0.4541015625 0.0040625 0.4541015625 0.004062502 0.48583984375 0.0040677 0.48583984375 0.004067702 0.52001953125 0.00407292 0.52001953125 0.004072922 0.555419921875 0.00407812 0.555419921875 0.004078122 0.59326171875 0.00408334 0.59326171875 0.004083342 0.63232421875 0.00408854 0.63232421875 0.004088542 0.673828125 0.00409376 0.673828125 0.004093762 0.716552734375 0.00409896 0.716552734375 0.004098962 0.76171875 0.00410416 0.76171875 0.004104162 0.80810546875 0.00410938 0.80810546875 0.004109382 0.855712890625 0.00411458 0.855712890625 0.004114582 0.904541015625 0.0041198 0.904541015625 0.004119802 0.955810546875 0.004125 0.955810546875 0.004125002 1.00830078125 0.0041302 1.00830078125 0.004130202 1.06201171875 0.00413542 1.06201171875 0.004135422 1.116943359375 0.00414062 1.116943359375 0.004140622 1.173095703125 0.00414584 1.173095703125 0.004145842 1.23046875 0.00415104 1.23046875 0.004151042 1.287841796875 0.00415624 1.287841796875 0.004156242 1.34765625 0.00416146 1.34765625 0.004161462 1.407470703125 0.00416666 1.407470703125 0.004166662 1.468505859375 0.00417188 1.468505859375 0.004171882 1.53076171875 0.00417708 1.53076171875 0.004177082 1.593017578125 0.0041823 1.593017578125 0.004182302 1.6552734375 0.0041875 1.6552734375 0.004187502 1.71875 0.0041927 1.71875 0.004192702 1.783447265625 0.00419792 1.783447265625 0.004197922 1.84814453125 0.00420312 1.84814453125 0.004203122 1.912841796875 0.00420834 1.912841796875 0.004208342 1.9775390625 0.00421354 1.9775390625 0.004213542 2.04345703125 0.00421876 2.04345703125 0.004218762 2.108154296875 0.00422396 2.108154296875 0.004223962 2.174072265625 0.00422916 2.174072265625 0.004229162 2.23876953125 0.00423438 2.23876953125 0.004234382 2.3046875 0.00423958 2.3046875 0.004239582 2.369384765625 0.0042448 2.369384765625 0.004244802 2.435302734375 0.00425 2.435302734375 0.004250002 2.5 0.0042552 2.5 0.004255202 2.5634765625 0.00426042 2.5634765625 0.004260422 2.626953125 0.00426562 2.626953125 0.004265622 2.6904296875 0.00427084 2.6904296875 0.004270842 2.75390625 0.00427604 2.75390625 0.004276042 2.81494140625 0.00428126 2.81494140625 0.004281262 2.877197265625 0.00428646 2.877197265625 0.004286462 2.93701171875 0.00429166 2.93701171875 0.004291662 2.996826171875 0.00429688 2.996826171875 0.004296882 3.055419921875 0.00430208 3.055419921875 0.004302082 3.11279296875 0.0043073 3.11279296875 0.004307302 3.170166015625 0.0043125 3.170166015625 0.004312502 3.226318359375 0.0043177 3.226318359375 0.004317702 3.280029296875 0.00432292 3.280029296875 0.004322922 3.333740234375 0.00432812 3.333740234375 0.004328122 3.38623046875 0.00433334 3.38623046875 0.004333342 3.436279296875 0.00433854 3.436279296875 0.004338542 3.486328125 0.00434376 3.486328125 0.004343762 3.533935546875 0.00434896 3.533935546875 0.004348962 3.58154296875 0.00435416 3.58154296875 0.004354162 3.626708984375 0.00435938 3.626708984375 0.004359382 3.670654296875 0.00436458 3.670654296875 0.004364582 3.712158203125 0.0043698 3.712158203125 0.004369802 3.75244140625 0.004375 3.75244140625 0.004375002 3.79150390625 0.0043802 3.79150390625 0.004380202 3.829345703125 0.00438542 3.829345703125 0.004385422 3.86474609375 0.00439062 3.86474609375 0.004390622 3.89892578125 0.00439584 3.89892578125 0.004395842 3.9306640625 0.00440104 3.9306640625 0.004401042 3.961181640625 0.00440624 3.961181640625 0.004406242 3.9892578125 0.00441146 3.9892578125 0.004411462 4.01611328125 0.00441666 4.01611328125 0.004416662 4.041748046875 0.00442188 4.041748046875 0.004421882 4.06494140625 0.00442708 4.06494140625 0.004427082 4.085693359375 0.0044323 4.085693359375 0.004432302 4.105224609375 0.0044375 4.105224609375 0.004437502 4.12353515625 0.0044427 4.12353515625 0.004442702 4.13818359375 0.00444792 4.13818359375 0.004447922 4.15283203125 0.00445312 4.15283203125 0.004453122 4.163818359375 0.00445834 4.163818359375 0.004458342 4.1748046875 0.00446354 4.1748046875 0.004463542 4.18212890625 0.00446874 4.18212890625 0.004468742 4.188232421875 0.00447396 4.188232421875 0.004473962 4.193115234375 0.00447916 4.193115234375 0.004479162 4.195556640625 0.00448958 4.195556640625 0.004489582 4.1943359375 0.0044948 4.1943359375 0.004494802 4.19189453125 0.0045 4.19189453125 0.004500002 4.18701171875 0.0045052 4.18701171875 0.004505202 4.1796875 0.00451042 4.1796875 0.004510422 4.171142578125 0.00451562 4.171142578125 0.004515622 4.161376953125 0.00452084 4.161376953125 0.004520842 4.149169921875 0.00452604 4.149169921875 0.004526042 4.134521484375 0.00453124 4.134521484375 0.004531242 4.119873046875 0.00453646 4.119873046875 0.004536462 4.102783203125 0.00454166 4.102783203125 0.004541662 4.083251953125 0.00454688 4.083251953125 0.004546882 4.063720703125 0.00455208 4.063720703125 0.004552082 4.041748046875 0.0045573 4.041748046875 0.004557302 4.0185546875 0.0045625 4.0185546875 0.004562502 3.992919921875 0.0045677 3.992919921875 0.004567702 3.96728515625 0.00457292 3.96728515625 0.004572922 3.939208984375 0.00457812 3.939208984375 0.004578122 3.909912109375 0.00458334 3.909912109375 0.004583342 3.87939453125 0.00458854 3.87939453125 0.004588542 3.84765625 0.00459376 3.84765625 0.004593762 3.814697265625 0.00459896 3.814697265625 0.004598962 3.780517578125 0.00460416 3.780517578125 0.004604162 3.7451171875 0.00460938 3.7451171875 0.004609382 3.70849609375 0.00461458 3.70849609375 0.004614582 3.670654296875 0.0046198 3.670654296875 0.004619802 3.6328125 0.004625 3.6328125 0.004625002 3.592529296875 0.0046302 3.592529296875 0.004630202 3.55224609375 0.00463542 3.55224609375 0.004635422 3.5107421875 0.00464062 3.5107421875 0.004640622 3.46923828125 0.00464584 3.46923828125 0.004645842 3.426513671875 0.00465104 3.426513671875 0.004651042 3.382568359375 0.00465624 3.382568359375 0.004656242 3.338623046875 0.00466146 3.338623046875 0.004661462 3.294677734375 0.00466666 3.294677734375 0.004666662 3.24951171875 0.00467188 3.24951171875 0.004671882 3.203125 0.00467708 3.203125 0.004677082 3.157958984375 0.0046823 3.157958984375 0.004682302 3.111572265625 0.0046875 3.111572265625 0.004687502 3.06396484375 0.0046927 3.06396484375 0.004692702 3.017578125 0.00469792 3.017578125 0.004697922 2.969970703125 0.00470312 2.969970703125 0.004703122 2.92236328125 0.00470834 2.92236328125 0.004708342 2.874755859375 0.00471354 2.874755859375 0.004713542 2.828369140625 0.00471876 2.828369140625 0.004718762 2.78076171875 0.00472396 2.78076171875 0.004723962 2.733154296875 0.00472916 2.733154296875 0.004729162 2.685546875 0.00473438 2.685546875 0.004734382 2.63916015625 0.00473958 2.63916015625 0.004739582 2.591552734375 0.0047448 2.591552734375 0.004744802 2.545166015625 0.00475 2.545166015625 0.004750002 2.5 0.0047552 2.5 0.004755202 2.45361328125 0.00476042 2.45361328125 0.004760422 2.408447265625 0.00476562 2.408447265625 0.004765622 2.36328125 0.00477084 2.36328125 0.004770842 2.3193359375 0.00477604 2.3193359375 0.004776042 2.275390625 0.00478124 2.275390625 0.004781242 2.2314453125 0.00478646 2.2314453125 0.004786462 2.18994140625 0.00479166 2.18994140625 0.004791662 2.147216796875 0.00479688 2.147216796875 0.004796882 2.10693359375 0.00480208 2.10693359375 0.004802082 2.066650390625 0.0048073 2.066650390625 0.004807302 2.0263671875 0.0048125 2.0263671875 0.004812502 1.988525390625 0.0048177 1.988525390625 0.004817702 1.95068359375 0.00482292 1.95068359375 0.004822922 1.9140625 0.00482812 1.9140625 0.004828122 1.878662109375 0.00483334 1.878662109375 0.004833342 1.84326171875 0.00483854 1.84326171875 0.004838542 1.80908203125 0.00484376 1.80908203125 0.004843762 1.77734375 0.00484896 1.77734375 0.004848962 1.74560546875 0.00485416 1.74560546875 0.004854162 1.715087890625 0.00485938 1.715087890625 0.004859382 1.685791015625 0.00486458 1.685791015625 0.004864582 1.65771484375 0.0048698 1.65771484375 0.004869802 1.630859375 0.004875 1.630859375 0.004875002 1.605224609375 0.0048802 1.605224609375 0.004880202 1.57958984375 0.00488542 1.57958984375 0.004885422 1.556396484375 0.00489062 1.556396484375 0.004890622 1.534423828125 0.00489584 1.534423828125 0.004895842 1.513671875 0.00490104 1.513671875 0.004901042 1.494140625 0.00490624 1.494140625 0.004906242 1.47705078125 0.00491146 1.47705078125 0.004911462 1.4599609375 0.00491666 1.4599609375 0.004916662 1.444091796875 0.00492188 1.444091796875 0.004921882 1.429443359375 0.00492708 1.429443359375 0.004927082 1.417236328125 0.0049323 1.417236328125 0.004932302 1.405029296875 0.0049375 1.405029296875 0.004937502 1.395263671875 0.0049427 1.395263671875 0.004942702 1.38671875 0.00494792 1.38671875 0.004947922 1.37939453125 0.00495312 1.37939453125 0.004953122 1.3720703125 0.00495834 1.3720703125 0.004958342 1.3671875 0.00496354 1.3671875 0.004963542 1.363525390625 0.00496876 1.363525390625 0.004968762 1.3623046875 0.00497396 1.3623046875 0.004973962 1.361083984375 0.00498438 1.361083984375 0.004984382 1.3623046875 0.00498958 1.3623046875 0.004989582 1.365966796875 0.0049948 1.365966796875 0.004994802 1.36962890625 0.005 1.36962890625 0.005000002 1.37451171875 0.0050052 1.37451171875 0.005005202 1.380615234375 0.00501042 1.380615234375 0.005010422 1.38916015625 0.00501562 1.38916015625 0.005015622 1.397705078125 0.00502084 1.397705078125 0.005020842 1.407470703125 0.00502604 1.407470703125 0.005026042 1.41845703125 0.00503124 1.41845703125 0.005031242 1.4306640625 0.00503646 1.4306640625 0.005036462 1.444091796875 0.00504166 1.444091796875 0.005041662 1.458740234375 0.00504688 1.458740234375 0.005046882 1.473388671875 0.00505208 1.473388671875 0.005052082 1.4892578125 0.0050573 1.4892578125 0.005057302 1.507568359375 0.0050625 1.507568359375 0.005062502 1.524658203125 0.0050677 1.524658203125 0.005067702 1.544189453125 0.00507292 1.544189453125 0.005072922 1.563720703125 0.00507812 1.563720703125 0.005078122 1.58447265625 0.00508334 1.58447265625 0.005083342 1.6064453125 0.00508854 1.6064453125 0.005088542 1.62841796875 0.00509376 1.62841796875 0.005093762 1.651611328125 0.00509896 1.651611328125 0.005098962 1.676025390625 0.00510416 1.676025390625 0.005104162 1.700439453125 0.00510938 1.700439453125 0.005109382 1.724853515625 0.00511458 1.724853515625 0.005114582 1.75048828125 0.0051198 1.75048828125 0.005119802 1.77734375 0.005125 1.77734375 0.005125002 1.802978515625 0.0051302 1.802978515625 0.005130202 1.8310546875 0.00513542 1.8310546875 0.005135422 1.85791015625 0.00514062 1.85791015625 0.005140622 1.885986328125 0.00514584 1.885986328125 0.005145842 1.9140625 0.00515104 1.9140625 0.005151042 1.943359375 0.00515624 1.943359375 0.005156242 1.97265625 0.00516146 1.97265625 0.005161462 2.001953125 0.00516666 2.001953125 0.005166662 2.03125 0.00517188 2.03125 0.005171882 2.060546875 0.00517708 2.060546875 0.005177082 2.08984375 0.0051823 2.08984375 0.005182302 2.120361328125 0.0051875 2.120361328125 0.005187502 2.149658203125 0.0051927 2.149658203125 0.005192702 2.178955078125 0.00519792 2.178955078125 0.005197922 2.20947265625 0.00520312 2.20947265625 0.005203122 2.23876953125 0.00520834 2.23876953125 0.005208342 2.269287109375 0.00521354 2.269287109375 0.005213542 2.298583984375 0.00521876 2.298583984375 0.005218762 2.327880859375 0.00522396 2.327880859375 0.005223962 2.357177734375 0.00522916 2.357177734375 0.005229162 2.386474609375 0.00523438 2.386474609375 0.005234382 2.41455078125 0.00523958 2.41455078125 0.005239582 2.44384765625 0.0052448 2.44384765625 0.005244802 2.471923828125 0.00525 2.471923828125 0.005250002 2.5 0.0052552 2.5 0.005255202 2.52685546875 0.00526042 2.52685546875 0.005260422 2.5537109375 0.00526562 2.5537109375 0.005265622 2.58056640625 0.00527084 2.58056640625 0.005270842 2.606201171875 0.00527604 2.606201171875 0.005276042 2.6318359375 0.00528124 2.6318359375 0.005281242 2.657470703125 0.00528646 2.657470703125 0.005286462 2.681884765625 0.00529166 2.681884765625 0.005291662 2.705078125 0.00529688 2.705078125 0.005296882 2.7294921875 0.00530208 2.7294921875 0.005302082 2.75146484375 0.0053073 2.75146484375 0.005307302 2.7734375 0.0053125 2.7734375 0.005312502 2.79541015625 0.0053177 2.79541015625 0.005317702 2.816162109375 0.00532292 2.816162109375 0.005322922 2.835693359375 0.00532812 2.835693359375 0.005328122 2.855224609375 0.00533334 2.855224609375 0.005333342 2.874755859375 0.00533854 2.874755859375 0.005338542 2.891845703125 0.00534376 2.891845703125 0.005343762 2.908935546875 0.00534896 2.908935546875 0.005348962 2.926025390625 0.00535416 2.926025390625 0.005354162 2.94189453125 0.00535938 2.94189453125 0.005359382 2.95654296875 0.00536458 2.95654296875 0.005364582 2.97119140625 0.0053698 2.97119140625 0.005369802 2.9833984375 0.005375 2.9833984375 0.005375002 2.996826171875 0.0053802 2.996826171875 0.005380202 3.0078125 0.00538542 3.0078125 0.005385422 3.018798828125 0.00539062 3.018798828125 0.005390622 3.02978515625 0.00539584 3.02978515625 0.005395842 3.038330078125 0.00540104 3.038330078125 0.005401042 3.046875 0.00540624 3.046875 0.005406242 3.05419921875 0.00541146 3.05419921875 0.005411462 3.0615234375 0.00541666 3.0615234375 0.005416662 3.067626953125 0.00542188 3.067626953125 0.005421882 3.072509765625 0.00542708 3.072509765625 0.005427082 3.077392578125 0.0054323 3.077392578125 0.005432302 3.0810546875 0.0054375 3.0810546875 0.005437502 3.08349609375 0.0054427 3.08349609375 0.005442702 3.0859375 0.00544792 3.0859375 0.005447922 3.087158203125 0.00545312 3.087158203125 0.005453122 3.08837890625 0.00546354 3.08837890625 0.005463542 3.087158203125 0.00546876 3.087158203125 0.005468762 3.0859375 0.00547396 3.0859375 0.005473962 3.08349609375 0.00547916 3.08349609375 0.005479162 3.079833984375 0.00548438 3.079833984375 0.005484382 3.076171875 0.00548958 3.076171875 0.005489582 3.072509765625 0.0054948 3.072509765625 0.005494802 3.067626953125 0.0055 3.067626953125 0.005500002 3.0615234375 0.0055052 3.0615234375 0.005505202 3.055419921875 0.00551042 3.055419921875 0.005510422 3.04931640625 0.00551562 3.04931640625 0.005515622 3.0419921875 0.00552084 3.0419921875 0.005520842 3.033447265625 0.00552604 3.033447265625 0.005526042 3.02490234375 0.00553124 3.02490234375 0.005531242 3.016357421875 0.00553646 3.016357421875 0.005536462 3.006591796875 0.00554166 3.006591796875 0.005541662 2.996826171875 0.00554688 2.996826171875 0.005546882 2.987060546875 0.00555208 2.987060546875 0.005552082 2.97607421875 0.0055573 2.97607421875 0.005557302 2.965087890625 0.0055625 2.965087890625 0.005562502 2.9541015625 0.0055677 2.9541015625 0.005567702 2.94189453125 0.00557292 2.94189453125 0.005572922 2.9296875 0.00557812 2.9296875 0.005578122 2.91748046875 0.00558334 2.91748046875 0.005583342 2.9052734375 0.00558854 2.9052734375 0.005588542 2.891845703125 0.00559376 2.891845703125 0.005593762 2.879638671875 0.00559896 2.879638671875 0.005598962 2.8662109375 0.00560416 2.8662109375 0.005604162 2.852783203125 0.00560938 2.852783203125 0.005609382 2.83935546875 0.00561458 2.83935546875 0.005614582 2.82470703125 0.0056198 2.82470703125 0.005619802 2.811279296875 0.005625 2.811279296875 0.005625002 2.7978515625 0.0056302 2.7978515625 0.005630202 2.783203125 0.00563542 2.783203125 0.005635422 2.769775390625 0.00564062 2.769775390625 0.005640622 2.75634765625 0.00564584 2.75634765625 0.005645842 2.74169921875 0.00565104 2.74169921875 0.005651042 2.728271484375 0.00565624 2.728271484375 0.005656242 2.713623046875 0.00566146 2.713623046875 0.005661462 2.7001953125 0.00566666 2.7001953125 0.005666662 2.686767578125 0.00567188 2.686767578125 0.005671882 2.67333984375 0.00567708 2.67333984375 0.005677082 2.659912109375 0.0056823 2.659912109375 0.005682302 2.646484375 0.0056875 2.646484375 0.005687502 2.63427734375 0.0056927 2.63427734375 0.005692702 2.620849609375 0.00569792 2.620849609375 0.005697922 2.608642578125 0.00570312 2.608642578125 0.005703122 2.596435546875 0.00570834 2.596435546875 0.005708342 2.584228515625 0.00571354 2.584228515625 0.005713542 2.572021484375 0.00571876 2.572021484375 0.005718762 2.56103515625 0.00572396 2.56103515625 0.005723962 2.550048828125 0.00572916 2.550048828125 0.005729162 2.5390625 0.00573438 2.5390625 0.005734382 2.528076171875 0.00573958 2.528076171875 0.005739582 2.518310546875 0.0057448 2.518310546875 0.005744802 2.508544921875 0.00575 2.508544921875 0.005750002 2.5 0.0057552 2.5 0.005755202 2.490234375 0.00576042 2.490234375 0.005760422 2.481689453125 0.00576562 2.481689453125 0.005765622 2.47314453125 0.00577084 2.47314453125 0.005770842 2.4658203125 0.00577604 2.4658203125 0.005776042 2.45849609375 0.00578124 2.45849609375 0.005781242 2.451171875 0.00578646 2.451171875 0.005786462 2.445068359375 0.00579166 2.445068359375 0.005791662 2.43896484375 0.00579688 2.43896484375 0.005796882 2.432861328125 0.00580208 2.432861328125 0.005802082 2.427978515625 0.0058073 2.427978515625 0.005807302 2.423095703125 0.0058125 2.423095703125 0.005812502 2.418212890625 0.0058177 2.418212890625 0.005817702 2.41455078125 0.00582292 2.41455078125 0.005822922 2.410888671875 0.00582812 2.410888671875 0.005828122 2.408447265625 0.00583334 2.408447265625 0.005833342 2.406005859375 0.00583854 2.406005859375 0.005838542 2.403564453125 0.00584376 2.403564453125 0.005843762 2.40234375 0.00584896 2.40234375 0.005848962 2.39990234375 0.00585938 2.39990234375 0.005859382 2.398681640625 0.005875 2.398681640625 0.005875002 2.39990234375 0.0058802 2.39990234375 0.005880202 2.401123046875 0.00588542 2.401123046875 0.005885422 2.40234375 0.00589062 2.40234375 0.005890622 2.40478515625 0.00589584 2.40478515625 0.005895842 2.406005859375 0.00590104 2.406005859375 0.005901042 2.408447265625 0.00590624 2.408447265625 0.005906242 2.412109375 0.00591146 2.412109375 0.005911462 2.41455078125 0.00591666 2.41455078125 0.005916662 2.418212890625 0.00592188 2.418212890625 0.005921882 2.421875 0.00592708 2.421875 0.005927082 2.425537109375 0.0059323 2.425537109375 0.005932302 2.430419921875 0.0059375 2.430419921875 0.005937502 2.43408203125 0.0059427 2.43408203125 0.005942702 2.43896484375 0.00594792 2.43896484375 0.005947922 2.44384765625 0.00595312 2.44384765625 0.005953122 2.44873046875 0.00595834 2.44873046875 0.005958342 2.45361328125 0.00596354 2.45361328125 0.005963542 2.459716796875 0.00596876 2.459716796875 0.005968762 2.464599609375 0.00597396 2.464599609375 0.005973962 2.470703125 0.00597916 2.470703125 0.005979162 2.4755859375 0.00598438 2.4755859375 0.005984382 2.481689453125 0.00598958 2.481689453125 0.005989582 2.48779296875 0.0059948 2.48779296875 0.005994802 2.493896484375 0.006 2.493896484375 0.006000002 2.5 0.0060052 2.5 0.006005202 2.49267578125 0.00601042 2.49267578125 0.006010422 2.486572265625 0.00601562 2.486572265625 0.006015622 2.48046875 0.00602084 2.48046875 0.006020842 2.47314453125 0.00602604 2.47314453125 0.006026042 2.467041015625 0.00603124 2.467041015625 0.006031242 2.4609375 0.00603646 2.4609375 0.006036462 2.45361328125 0.00604166 2.45361328125 0.006041662 2.447509765625 0.00604688 2.447509765625 0.006046882 2.44140625 0.00605208 2.44140625 0.006052082 2.43408203125 0.0060573 2.43408203125 0.006057302 2.427978515625 0.0060625 2.427978515625 0.006062502 2.421875 0.0060677 2.421875 0.006067702 2.41455078125 0.00607292 2.41455078125 0.006072922 2.408447265625 0.00607812 2.408447265625 0.006078122 2.40234375 0.00608334 2.40234375 0.006083342 2.39501953125 0.00608854 2.39501953125 0.006088542 2.388916015625 0.00609376 2.388916015625 0.006093762 2.3828125 0.00609896 2.3828125 0.006098962 2.37548828125 0.00610416 2.37548828125 0.006104162 2.369384765625 0.00610938 2.369384765625 0.006109382 2.36328125 0.00611458 2.36328125 0.006114582 2.35595703125 0.0061198 2.35595703125 0.006119802 2.349853515625 0.006125 2.349853515625 0.006125002 2.34375 0.0061302 2.34375 0.006130202 2.33642578125 0.00613542 2.33642578125 0.006135422 2.330322265625 0.00614062 2.330322265625 0.006140622 2.32421875 0.00614584 2.32421875 0.006145842 2.31689453125 0.00615104 2.31689453125 0.006151042 2.310791015625 0.00615624 2.310791015625 0.006156242 2.3046875 0.00616146 2.3046875 0.006161462 2.29736328125 0.00616666 2.29736328125 0.006166662 2.291259765625 0.00617188 2.291259765625 0.006171882 2.28515625 0.00617708 2.28515625 0.006177082 2.27783203125 0.0061823 2.27783203125 0.006182302 2.271728515625 0.0061875 2.271728515625 0.006187502 2.265625 0.0061927 2.265625 0.006192702 2.25830078125 0.00619792 2.25830078125 0.006197922 2.252197265625 0.00620312 2.252197265625 0.006203122 2.24609375 0.00620834 2.24609375 0.006208342 2.23876953125 0.00621354 2.23876953125 0.006213542 2.232666015625 0.00621876 2.232666015625 0.006218762 2.2265625 0.00622396 2.2265625 0.006223962 2.21923828125 0.00622916 2.21923828125 0.006229162 2.213134765625 0.00623438 2.213134765625 0.006234382 2.20703125 0.00623958 2.20703125 0.006239582 2.19970703125 0.0062448 2.19970703125 0.006244802 2.193603515625 0.00625 2.193603515625 0.006250002 2.1875 0.0062552 2.1875 0.006255202 2.18017578125 0.00626042 2.18017578125 0.006260422 2.174072265625 0.00626562 2.174072265625 0.006265622 2.16796875 0.00627084 2.16796875 0.006270842 2.16064453125 0.00627604 2.16064453125 0.006276042 2.154541015625 0.00628124 2.154541015625 0.006281242 2.1484375 0.00628646 2.1484375 0.006286462 2.14111328125 0.00629166 2.14111328125 0.006291662 2.135009765625 0.00629688 2.135009765625 0.006296882 2.12890625 0.00630208 2.12890625 0.006302082 2.12158203125 0.0063073 2.12158203125 0.006307302 2.115478515625 0.0063125 2.115478515625 0.006312502 2.109375 0.0063177 2.109375 0.006317702 2.10205078125 0.00632292 2.10205078125 0.006322922 2.095947265625 0.00632812 2.095947265625 0.006328122 2.08984375 0.00633334 2.08984375 0.006333342 2.08251953125 0.00633854 2.08251953125 0.006338542 2.076416015625 0.00634376 2.076416015625 0.006343762 2.0703125 0.00634896 2.0703125 0.006348962 2.06298828125 0.00635416 2.06298828125 0.006354162 2.056884765625 0.00635938 2.056884765625 0.006359382 2.05078125 0.00636458 2.05078125 0.006364582 2.04345703125 0.0063698 2.04345703125 0.006369802 2.037353515625 0.006375 2.037353515625 0.006375002 2.03125 0.0063802 2.03125 0.006380202 2.02392578125 0.00638542 2.02392578125 0.006385422 2.017822265625 0.00639062 2.017822265625 0.006390622 2.01171875 0.00639584 2.01171875 0.006395842 2.00439453125 0.00640104 2.00439453125 0.006401042 1.998291015625 0.00640624 1.998291015625 0.006406242 1.9921875 0.00641146 1.9921875 0.006411462 1.98486328125 0.00641666 1.98486328125 0.006416662 1.978759765625 0.00642188 1.978759765625 0.006421882 1.97265625 0.00642708 1.97265625 0.006427082 1.96533203125 0.0064323 1.96533203125 0.006432302 1.959228515625 0.0064375 1.959228515625 0.006437502 1.953125 0.0064427 1.953125 0.006442702 1.94580078125 0.00644792 1.94580078125 0.006447922 1.939697265625 0.00645312 1.939697265625 0.006453122 1.93359375 0.00645834 1.93359375 0.006458342 1.92626953125 0.00646354 1.92626953125 0.006463542 1.920166015625 0.00646876 1.920166015625 0.006468762 1.9140625 0.00647396 1.9140625 0.006473962 1.90673828125 0.00647916 1.90673828125 0.006479162 1.900634765625 0.00648438 1.900634765625 0.006484382 1.89453125 0.00648958 1.89453125 0.006489582 1.88720703125 0.0064948 1.88720703125 0.006494802 1.881103515625 0.0065 1.881103515625 0.006500002 1.875 0.0065052 1.875 0.006505202 1.86767578125 0.00651042 1.86767578125 0.006510422 1.861572265625 0.00651562 1.861572265625 0.006515622 1.85546875 0.00652084 1.85546875 0.006520842 1.84814453125 0.00652604 1.84814453125 0.006526042 1.842041015625 0.00653124 1.842041015625 0.006531242 1.8359375 0.00653646 1.8359375 0.006536462 1.82861328125 0.00654166 1.82861328125 0.006541662 1.822509765625 0.00654688 1.822509765625 0.006546882 1.81640625 0.00655208 1.81640625 0.006552082 1.80908203125 0.0065573 1.80908203125 0.006557302 1.802978515625 0.0065625 1.802978515625 0.006562502 1.796875 0.0065677 1.796875 0.006567702 1.78955078125 0.00657292 1.78955078125 0.006572922 1.783447265625 0.00657812 1.783447265625 0.006578122 1.77734375 0.00658334 1.77734375 0.006583342 1.77001953125 0.00658854 1.77001953125 0.006588542 1.763916015625 0.00659376 1.763916015625 0.006593762 1.7578125 0.00659896 1.7578125 0.006598962 1.75048828125 0.00660416 1.75048828125 0.006604162 1.744384765625 0.00660938 1.744384765625 0.006609382 1.73828125 0.00661458 1.73828125 0.006614582 1.73095703125 0.0066198 1.73095703125 0.006619802 1.724853515625 0.006625 1.724853515625 0.006625002 1.71875 0.0066302 1.71875 0.006630202 1.71142578125 0.00663542 1.71142578125 0.006635422 1.705322265625 0.00664062 1.705322265625 0.006640622 1.69921875 0.00664584 1.69921875 0.006645842 1.69189453125 0.00665104 1.69189453125 0.006651042 1.685791015625 0.00665624 1.685791015625 0.006656242 1.6796875 0.00666146 1.6796875 0.006661462 1.67236328125 0.00666666 1.67236328125 0.006666662 1.666259765625 0.00667188 1.666259765625 0.006671882 1.66015625 0.00667708 1.66015625 0.006677082 1.65283203125 0.0066823 1.65283203125 0.006682302 1.646728515625 0.0066875 1.646728515625 0.006687502 1.640625 0.0066927 1.640625 0.006692702 1.63330078125 0.00669792 1.63330078125 0.006697922 1.627197265625 0.00670312 1.627197265625 0.006703122 1.62109375 0.00670834 1.62109375 0.006708342 1.61376953125 0.00671354 1.61376953125 0.006713542 1.607666015625 0.00671876 1.607666015625 0.006718762 1.6015625 0.00672396 1.6015625 0.006723962 1.59423828125 0.00672916 1.59423828125 0.006729162 1.588134765625 0.00673438 1.588134765625 0.006734382 1.58203125 0.00673958 1.58203125 0.006739582 1.57470703125 0.0067448 1.57470703125 0.006744802 1.568603515625 0.00675 1.568603515625 0.006750002 1.5625 0.0067552 1.5625 0.006755202 1.55517578125 0.00676042 1.55517578125 0.006760422 1.549072265625 0.00676562 1.549072265625 0.006765622 1.54296875 0.00677084 1.54296875 0.006770842 1.53564453125 0.00677604 1.53564453125 0.006776042 1.529541015625 0.00678124 1.529541015625 0.006781242 1.5234375 0.00678646 1.5234375 0.006786462 1.51611328125 0.00679166 1.51611328125 0.006791662 1.510009765625 0.00679688 1.510009765625 0.006796882 1.50390625 0.00680208 1.50390625 0.006802082 1.49658203125 0.0068073 1.49658203125 0.006807302 1.490478515625 0.0068125 1.490478515625 0.006812502 1.484375 0.0068177 1.484375 0.006817702 1.47705078125 0.00682292 1.47705078125 0.006822922 1.470947265625 0.00682812 1.470947265625 0.006828122 1.46484375 0.00683334 1.46484375 0.006833342 1.45751953125 0.00683854 1.45751953125 0.006838542 1.451416015625 0.00684376 1.451416015625 0.006843762 1.4453125 0.00684896 1.4453125 0.006848962 1.43798828125 0.00685416 1.43798828125 0.006854162 1.431884765625 0.00685938 1.431884765625 0.006859382 1.42578125 0.00686458 1.42578125 0.006864582 1.41845703125 0.0068698 1.41845703125 0.006869802 1.412353515625 0.006875 1.412353515625 0.006875002 1.40625 0.0068802 1.40625 0.006880202 1.39892578125 0.00688542 1.39892578125 0.006885422 1.392822265625 0.00689062 1.392822265625 0.006890622 1.38671875 0.00689584 1.38671875 0.006895842 1.37939453125 0.00690104 1.37939453125 0.006901042 1.373291015625 0.00690624 1.373291015625 0.006906242 1.3671875 0.00691146 1.3671875 0.006911462 1.35986328125 0.00691666 1.35986328125 0.006916662 1.353759765625 0.00692188 1.353759765625 0.006921882 1.34765625 0.00692708 1.34765625 0.006927082 1.34033203125 0.0069323 1.34033203125 0.006932302 1.334228515625 0.0069375 1.334228515625 0.006937502 1.328125 0.0069427 1.328125 0.006942702 1.32080078125 0.00694792 1.32080078125 0.006947922 1.314697265625 0.00695312 1.314697265625 0.006953122 1.30859375 0.00695834 1.30859375 0.006958342 1.30126953125 0.00696354 1.30126953125 0.006963542 1.295166015625 0.00696876 1.295166015625 0.006968762 1.2890625 0.00697396 1.2890625 0.006973962 1.28173828125 0.00697916 1.28173828125 0.006979162 1.275634765625 0.00698438 1.275634765625 0.006984382 1.26953125 0.00698958 1.26953125 0.006989582 1.26220703125 0.0069948 1.26220703125 0.006994802 1.256103515625 0.007 1.256103515625 0.007000002 1.25 0.0070052 1.25 0.007005202 1.24267578125 0.00701042 1.24267578125 0.007010422 1.236572265625 0.00701562 1.236572265625 0.007015622 1.23046875 0.00702084 1.23046875 0.007020842 1.22314453125 0.00702604 1.22314453125 0.007026042 1.217041015625 0.00703124 1.217041015625 0.007031242 1.2109375 0.00703646 1.2109375 0.007036462 1.20361328125 0.00704166 1.20361328125 0.007041662 1.197509765625 0.00704688 1.197509765625 0.007046882 1.19140625 0.00705208 1.19140625 0.007052082 1.18408203125 0.0070573 1.18408203125 0.007057302 1.177978515625 0.0070625 1.177978515625 0.007062502 1.171875 0.0070677 1.171875 0.007067702 1.16455078125 0.00707292 1.16455078125 0.007072922 1.158447265625 0.00707812 1.158447265625 0.007078122 1.15234375 0.00708334 1.15234375 0.007083342 1.14501953125 0.00708854 1.14501953125 0.007088542 1.138916015625 0.00709376 1.138916015625 0.007093762 1.1328125 0.00709896 1.1328125 0.007098962 1.12548828125 0.00710416 1.12548828125 0.007104162 1.119384765625 0.00710938 1.119384765625 0.007109382 1.11328125 0.00711458 1.11328125 0.007114582 1.10595703125 0.0071198 1.10595703125 0.007119802 1.099853515625 0.007125 1.099853515625 0.007125002 1.09375 0.0071302 1.09375 0.007130202 1.08642578125 0.00713542 1.08642578125 0.007135422 1.080322265625 0.00714062 1.080322265625 0.007140622 1.07421875 0.00714584 1.07421875 0.007145842 1.06689453125 0.00715104 1.06689453125 0.007151042 1.060791015625 0.00715624 1.060791015625 0.007156242 1.0546875 0.00716146 1.0546875 0.007161462 1.04736328125 0.00716666 1.04736328125 0.007166662 1.041259765625 0.00717188 1.041259765625 0.007171882 1.03515625 0.00717708 1.03515625 0.007177082 1.02783203125 0.0071823 1.02783203125 0.007182302 1.021728515625 0.0071875 1.021728515625 0.007187502 1.015625 0.0071927 1.015625 0.007192702 1.00830078125 0.00719792 1.00830078125 0.007197922 1.002197265625 0.00720312 1.002197265625 0.007203122 0.99609375 0.00720834 0.99609375 0.007208342 0.98876953125 0.00721354 0.98876953125 0.007213542 0.982666015625 0.00721876 0.982666015625 0.007218762 0.9765625 0.00722396 0.9765625 0.007223962 0.96923828125 0.00722916 0.96923828125 0.007229162 0.963134765625 0.00723438 0.963134765625 0.007234382 0.95703125 0.00723958 0.95703125 0.007239582 0.94970703125 0.0072448 0.94970703125 0.007244802 0.943603515625 0.00725 0.943603515625 0.007250002 0.9375 0.0072552 0.9375 0.007255202 0.93017578125 0.00726042 0.93017578125 0.007260422 0.924072265625 0.00726562 0.924072265625 0.007265622 0.91796875 0.00727084 0.91796875 0.007270842 0.91064453125 0.00727604 0.91064453125 0.007276042 0.904541015625 0.00728124 0.904541015625 0.007281242 0.8984375 0.00728646 0.8984375 0.007286462 0.89111328125 0.00729166 0.89111328125 0.007291662 0.885009765625 0.00729688 0.885009765625 0.007296882 0.87890625 0.00730208 0.87890625 0.007302082 0.87158203125 0.0073073 0.87158203125 0.007307302 0.865478515625 0.0073125 0.865478515625 0.007312502 0.859375 0.0073177 0.859375 0.007317702 0.853271484375 0.00732292 0.853271484375 0.007322922 0.845947265625 0.00732812 0.845947265625 0.007328122 0.83984375 0.00733334 0.83984375 0.007333342 0.83251953125 0.00733854 0.83251953125 0.007338542 0.826416015625 0.00734376 0.826416015625 0.007343762 0.8203125 0.00734896 0.8203125 0.007348962 0.814208984375 0.00735416 0.814208984375 0.007354162 0.806884765625 0.00735938 0.806884765625 0.007359382 0.80078125 0.00736458 0.80078125 0.007364582 0.794677734375 0.0073698 0.794677734375 0.007369802 0.787353515625 0.007375 0.787353515625 0.007375002 0.78125 0.0073802 0.78125 0.007380202 0.775146484375 0.00738542 0.775146484375 0.007385422 0.767822265625 0.00739062 0.767822265625 0.007390622 0.76171875 0.00739584 0.76171875 0.007395842 0.755615234375 0.00740104 0.755615234375 0.007401042 0.748291015625 0.00740624 0.748291015625 0.007406242 0.7421875 0.00741146 0.7421875 0.007411462 0.736083984375 0.00741666 0.736083984375 0.007416662 0.728759765625 0.00742188 0.728759765625 0.007421882 0.72265625 0.00742708 0.72265625 0.007427082 0.716552734375 0.0074323 0.716552734375 0.007432302 0.709228515625 0.0074375 0.709228515625 0.007437502 0.703125 0.0074427 0.703125 0.007442702 0.697021484375 0.00744792 0.697021484375 0.007447922 0.689697265625 0.00745312 0.689697265625 0.007453122 0.68359375 0.00745834 0.68359375 0.007458342 0.677490234375 0.00746354 0.677490234375 0.007463542 0.670166015625 0.00746876 0.670166015625 0.007468762 0.6640625 0.00747396 0.6640625 0.007473962 0.657958984375 0.00747916 0.657958984375 0.007479162 0.650634765625 0.00748438 0.650634765625 0.007484382 0.64453125 0.00748958 0.64453125 0.007489582 0.638427734375 0.0074948 0.638427734375 0.007494802 0.631103515625 0.0075 0.631103515625 0.007500002 0.625 0.0075052 0.625 0.007505202 0.618896484375 0.00751042 0.618896484375 0.007510422 0.611572265625 0.00751562 0.611572265625 0.007515622 0.60546875 0.00752084 0.60546875 0.007520842 0.599365234375 0.00752604 0.599365234375 0.007526042 0.592041015625 0.00753124 0.592041015625 0.007531242 0.5859375 0.00753646 0.5859375 0.007536462 0.579833984375 0.00754166 0.579833984375 0.007541662 0.572509765625 0.00754688 0.572509765625 0.007546882 0.56640625 0.00755208 0.56640625 0.007552082 0.560302734375 0.0075573 0.560302734375 0.007557302 0.552978515625 0.0075625 0.552978515625 0.007562502 0.546875 0.0075677 0.546875 0.007567702 0.540771484375 0.00757292 0.540771484375 0.007572922 0.533447265625 0.00757812 0.533447265625 0.007578122 0.52734375 0.00758334 0.52734375 0.007583342 0.521240234375 0.00758854 0.521240234375 0.007588542 0.513916015625 0.00759376 0.513916015625 0.007593762 0.5078125 0.00759896 0.5078125 0.007598962 0.501708984375 0.00760416 0.501708984375 0.007604162 0.494384765625 0.00760938 0.494384765625 0.007609382 0.48828125 0.00761458 0.48828125 0.007614582 0.482177734375 0.0076198 0.482177734375 0.007619802 0.474853515625 0.007625 0.474853515625 0.007625002 0.46875 0.0076302 0.46875 0.007630202 0.462646484375 0.00763542 0.462646484375 0.007635422 0.455322265625 0.00764062 0.455322265625 0.007640622 0.44921875 0.00764584 0.44921875 0.007645842 0.443115234375 0.00765104 0.443115234375 0.007651042 0.435791015625 0.00765624 0.435791015625 0.007656242 0.4296875 0.00766146 0.4296875 0.007661462 0.423583984375 0.00766666 0.423583984375 0.007666662 0.416259765625 0.00767188 0.416259765625 0.007671882 0.41015625 0.00767708 0.41015625 0.007677082 0.404052734375 0.0076823 0.404052734375 0.007682302 0.396728515625 0.0076875 0.396728515625 0.007687502 0.390625 0.0076927 0.390625 0.007692702 0.384521484375 0.00769792 0.384521484375 0.007697922 0.377197265625 0.00770312 0.377197265625 0.007703122 0.37109375 0.00770834 0.37109375 0.007708342 0.364990234375 0.00771354 0.364990234375 0.007713542 0.357666015625 0.00771876 0.357666015625 0.007718762 0.3515625 0.00772396 0.3515625 0.007723962 0.345458984375 0.00772916 0.345458984375 0.007729162 0.338134765625 0.00773438 0.338134765625 0.007734382 0.33203125 0.00773958 0.33203125 0.007739582 0.325927734375 0.0077448 0.325927734375 0.007744802 0.318603515625 0.00775 0.318603515625 0.007750002 0.3125 0.0077552 0.3125 0.007755202 0.306396484375 0.00776042 0.306396484375 0.007760422 0.299072265625 0.00776562 0.299072265625 0.007765622 0.29296875 0.00777084 0.29296875 0.007770842 0.286865234375 0.00777604 0.286865234375 0.007776042 0.279541015625 0.00778124 0.279541015625 0.007781242 0.2734375 0.00778646 0.2734375 0.007786462 0.267333984375 0.00779166 0.267333984375 0.007791662 0.260009765625 0.00779688 0.260009765625 0.007796882 0.25390625 0.00780208 0.25390625 0.007802082 0.247802734375 0.0078073 0.247802734375 0.007807302 0.240478515625 0.0078125 0.240478515625 0.007812502 0.234375 0.0078177 0.234375 0.007817702 0.228271484375 0.00782292 0.228271484375 0.007822922 0.220947265625 0.00782812 0.220947265625 0.007828122 0.21484375 0.00783334 0.21484375 0.007833342 0.208740234375 0.00783854 0.208740234375 0.007838542 0.201416015625 0.00784376 0.201416015625 0.007843762 0.1953125 0.00784896 0.1953125 0.007848962 0.189208984375 0.00785416 0.189208984375 0.007854162 0.181884765625 0.00785938 0.181884765625 0.007859382 0.17578125 0.00786458 0.17578125 0.007864582 0.169677734375 0.0078698 0.169677734375 0.007869802 0.162353515625 0.007875 0.162353515625 0.007875002 0.15625 0.0078802 0.15625 0.007880202 0.150146484375 0.00788542 0.150146484375 0.007885422 0.142822265625 0.00789062 0.142822265625 0.007890622 0.13671875 0.00789584 0.13671875 0.007895842 0.130615234375 0.00790104 0.130615234375 0.007901042 0.123291015625 0.00790624 0.123291015625 0.007906242 0.1171875 0.00791146 0.1171875 0.007911462 0.111083984375 0.00791666 0.111083984375 0.007916662 0.103759765625 0.00792188 0.103759765625 0.007921882 0.09765625 0.00792708 0.09765625 0.007927082 0.091552734375 0.0079323 0.091552734375 0.007932302 0.084228515625 0.0079375 0.084228515625 0.007937502 0.078125 0.0079427 0.078125 0.007942702 0.072021484375 0.00794792 0.072021484375 0.007947922 0.064697265625 0.00795312 0.064697265625 0.007953122 0.05859375 0.00795834 0.05859375 0.007958342 0.052490234375 0.00796354 0.052490234375 0.007963542 0.045166015625 0.00796876 0.045166015625 0.007968762 0.0390625 0.00797396 0.0390625 0.007973962 0.032958984375 0.00797916 0.032958984375 0.007979162 0.025634765625 0.00798438 0.025634765625 0.007984382 0.01953125 0.00798958 0.01953125 0.007989582 0.013427734375 0.0079948 0.013427734375 0.007994802 0.006103515625 0.008 0.006103515625 0.008000002 0 0.0100052 0 0.010005202 0.006103515625 0.01001042 0.006103515625 0.010010422 0.013427734375 0.01001562 0.013427734375 0.010015622 0.01953125 0.01002084 0.01953125 0.010020842 0.025634765625 0.01002604 0.025634765625 0.010026042 0.032958984375 0.01003124 0.032958984375 0.010031242 0.0390625 0.01003646 0.0390625 0.010036462 0.045166015625 0.01004166 0.045166015625 0.010041662 0.052490234375 0.01004688 0.052490234375 0.010046882 0.05859375 0.01005208 0.05859375 0.010052082 0.064697265625 0.0100573 0.064697265625 0.010057302 0.072021484375 0.0100625 0.072021484375 0.010062502 0.078125 0.0100677 0.078125 0.010067702 0.084228515625 0.01007292 0.084228515625 0.010072922 0.091552734375 0.01007812 0.091552734375 0.010078122 0.09765625 0.01008334 0.09765625 0.010083342 0.103759765625 0.01008854 0.103759765625 0.010088542 0.111083984375 0.01009376 0.111083984375 0.010093762 0.1171875 0.01009896 0.1171875 0.010098962 0.123291015625 0.01010416 0.123291015625 0.010104162 0.130615234375 0.01010938 0.130615234375 0.010109382 0.13671875 0.01011458 0.13671875 0.010114582 0.142822265625 0.0101198 0.142822265625 0.010119802 0.150146484375 0.010125 0.150146484375 0.010125002 0.15625 0.0101302 0.15625 0.010130202 0.162353515625 0.01013542 0.162353515625 0.010135422 0.169677734375 0.01014062 0.169677734375 0.010140622 0.17578125 0.01014584 0.17578125 0.010145842 0.181884765625 0.01015104 0.181884765625 0.010151042 0.189208984375 0.01015624 0.189208984375 0.010156242 0.1953125 0.01016146 0.1953125 0.010161462 0.201416015625 0.01016666 0.201416015625 0.010166662 0.208740234375 0.01017188 0.208740234375 0.010171882 0.21484375 0.01017708 0.21484375 0.010177082 0.220947265625 0.0101823 0.220947265625 0.010182302 0.228271484375 0.0101875 0.228271484375 0.010187502 0.234375 0.0101927 0.234375 0.010192702 0.240478515625 0.01019792 0.240478515625 0.010197922 0.247802734375 0.01020312 0.247802734375 0.010203122 0.25390625 0.01020834 0.25390625 0.010208342 0.260009765625 0.01021354 0.260009765625 0.010213542 0.267333984375 0.01021876 0.267333984375 0.010218762 0.2734375 0.01022396 0.2734375 0.010223962 0.279541015625 0.01022916 0.279541015625 0.010229162 0.286865234375 0.01023438 0.286865234375 0.010234382 0.29296875 0.01023958 0.29296875 0.010239582 0.299072265625 0.0102448 0.299072265625 0.010244802 0.306396484375 0.01025 0.306396484375 0.010250002 0.3125 0.0102552 0.3125 0.010255202 0.318603515625 0.01026042 0.318603515625 0.010260422 0.325927734375 0.01026562 0.325927734375 0.010265622 0.33203125 0.01027084 0.33203125 0.010270842 0.338134765625 0.01027604 0.338134765625 0.010276042 0.345458984375 0.01028124 0.345458984375 0.010281242 0.3515625 0.01028646 0.3515625 0.010286462 0.357666015625 0.01029166 0.357666015625 0.010291662 0.364990234375 0.01029688 0.364990234375 0.010296882 0.37109375 0.01030208 0.37109375 0.010302082 0.377197265625 0.0103073 0.377197265625 0.010307302 0.384521484375 0.0103125 0.384521484375 0.010312502 0.390625 0.0103177 0.390625 0.010317702 0.396728515625 0.01032292 0.396728515625 0.010322922 0.404052734375 0.01032812 0.404052734375 0.010328122 0.41015625 0.01033334 0.41015625 0.010333342 0.416259765625 0.01033854 0.416259765625 0.010338542 0.423583984375 0.01034376 0.423583984375 0.010343762 0.4296875 0.01034896 0.4296875 0.010348962 0.435791015625 0.01035416 0.435791015625 0.010354162 0.443115234375 0.01035938 0.443115234375 0.010359382 0.44921875 0.01036458 0.44921875 0.010364582 0.455322265625 0.0103698 0.455322265625 0.010369802 0.462646484375 0.010375 0.462646484375 0.010375002 0.46875 0.0103802 0.46875 0.010380202 0.474853515625 0.01038542 0.474853515625 0.010385422 0.482177734375 0.01039062 0.482177734375 0.010390622 0.48828125 0.01039584 0.48828125 0.010395842 0.494384765625 0.01040104 0.494384765625 0.010401042 0.501708984375 0.01040624 0.501708984375 0.010406242 0.5078125 0.01041146 0.5078125 0.010411462 0.513916015625 0.01041666 0.513916015625 0.010416662 0.521240234375 0.01042188 0.521240234375 0.010421882 0.52734375 0.01042708 0.52734375 0.010427082 0.533447265625 0.0104323 0.533447265625 0.010432302 0.540771484375 0.0104375 0.540771484375 0.010437502 0.546875 0.0104427 0.546875 0.010442702 0.552978515625 0.01044792 0.552978515625 0.010447922 0.560302734375 0.01045312 0.560302734375 0.010453122 0.56640625 0.01045834 0.56640625 0.010458342 0.572509765625 0.01046354 0.572509765625 0.010463542 0.579833984375 0.01046876 0.579833984375 0.010468762 0.5859375 0.01047396 0.5859375 0.010473962 0.592041015625 0.01047916 0.592041015625 0.010479162 0.599365234375 0.01048438 0.599365234375 0.010484382 0.60546875 0.01048958 0.60546875 0.010489582 0.611572265625 0.0104948 0.611572265625 0.010494802 0.618896484375 0.0105 0.618896484375 0.010500002 0.625 0.0105052 0.625 0.010505202 0.631103515625 0.01051042 0.631103515625 0.010510422 0.638427734375 0.01051562 0.638427734375 0.010515622 0.64453125 0.01052084 0.64453125 0.010520842 0.650634765625 0.01052604 0.650634765625 0.010526042 0.657958984375 0.01053124 0.657958984375 0.010531242 0.6640625 0.01053646 0.6640625 0.010536462 0.670166015625 0.01054166 0.670166015625 0.010541662 0.677490234375 0.01054688 0.677490234375 0.010546882 0.68359375 0.01055208 0.68359375 0.010552082 0.689697265625 0.0105573 0.689697265625 0.010557302 0.697021484375 0.0105625 0.697021484375 0.010562502 0.703125 0.0105677 0.703125 0.010567702 0.709228515625 0.01057292 0.709228515625 0.010572922 0.716552734375 0.01057812 0.716552734375 0.010578122 0.72265625 0.01058334 0.72265625 0.010583342 0.728759765625 0.01058854 0.728759765625 0.010588542 0.736083984375 0.01059376 0.736083984375 0.010593762 0.7421875 0.01059896 0.7421875 0.010598962 0.748291015625 0.01060416 0.748291015625 0.010604162 0.755615234375 0.01060938 0.755615234375 0.010609382 0.76171875 0.01061458 0.76171875 0.010614582 0.767822265625 0.0106198 0.767822265625 0.010619802 0.775146484375 0.010625 0.775146484375 0.010625002 0.78125 0.0106302 0.78125 0.010630202 0.787353515625 0.01063542 0.787353515625 0.010635422 0.794677734375 0.01064062 0.794677734375 0.010640622 0.80078125 0.01064584 0.80078125 0.010645842 0.806884765625 0.01065104 0.806884765625 0.010651042 0.814208984375 0.01065624 0.814208984375 0.010656242 0.8203125 0.01066146 0.8203125 0.010661462 0.826416015625 0.01066666 0.826416015625 0.010666662 0.83251953125 0.01067188 0.83251953125 0.010671882 0.83984375 0.01067708 0.83984375 0.010677082 0.845947265625 0.0106823 0.845947265625 0.010682302 0.853271484375 0.0106875 0.853271484375 0.010687502 0.859375 0.0106927 0.859375 0.010692702 0.865478515625 0.01069792 0.865478515625 0.010697922 0.87158203125 0.01070312 0.87158203125 0.010703122 0.87890625 0.01070834 0.87890625 0.010708342 0.885009765625 0.01071354 0.885009765625 0.010713542 0.89111328125 0.01071876 0.89111328125 0.010718762 0.8984375 0.01072396 0.8984375 0.010723962 0.904541015625 0.01072916 0.904541015625 0.010729162 0.91064453125 0.01073438 0.91064453125 0.010734382 0.91796875 0.01073958 0.91796875 0.010739582 0.924072265625 0.0107448 0.924072265625 0.010744802 0.93017578125 0.01075 0.93017578125 0.010750002 0.9375 0.0107552 0.9375 0.010755202 0.943603515625 0.01076042 0.943603515625 0.010760422 0.94970703125 0.01076562 0.94970703125 0.010765622 0.95703125 0.01077084 0.95703125 0.010770842 0.963134765625 0.01077604 0.963134765625 0.010776042 0.96923828125 0.01078124 0.96923828125 0.010781242 0.9765625 0.01078646 0.9765625 0.010786462 0.982666015625 0.01079166 0.982666015625 0.010791662 0.98876953125 0.01079688 0.98876953125 0.010796882 0.99609375 0.01080208 0.99609375 0.010802082 1.002197265625 0.0108073 1.002197265625 0.010807302 1.00830078125 0.0108125 1.00830078125 0.010812502 1.015625 0.0108177 1.015625 0.010817702 1.021728515625 0.01082292 1.021728515625 0.010822922 1.02783203125 0.01082812 1.02783203125 0.010828122 1.03515625 0.01083334 1.03515625 0.010833342 1.041259765625 0.01083854 1.041259765625 0.010838542 1.04736328125 0.01084376 1.04736328125 0.010843762 1.0546875 0.01084896 1.0546875 0.010848962 1.060791015625 0.01085416 1.060791015625 0.010854162 1.06689453125 0.01085938 1.06689453125 0.010859382 1.07421875 0.01086458 1.07421875 0.010864582 1.080322265625 0.0108698 1.080322265625 0.010869802 1.08642578125 0.010875 1.08642578125 0.010875002 1.09375 0.0108802 1.09375 0.010880202 1.099853515625 0.01088542 1.099853515625 0.010885422 1.10595703125 0.01089062 1.10595703125 0.010890622 1.11328125 0.01089584 1.11328125 0.010895842 1.119384765625 0.01090104 1.119384765625 0.010901042 1.12548828125 0.01090624 1.12548828125 0.010906242 1.1328125 0.01091146 1.1328125 0.010911462 1.138916015625 0.01091666 1.138916015625 0.010916662 1.14501953125 0.01092188 1.14501953125 0.010921882 1.15234375 0.01092708 1.15234375 0.010927082 1.158447265625 0.0109323 1.158447265625 0.010932302 1.16455078125 0.0109375 1.16455078125 0.010937502 1.171875 0.0109427 1.171875 0.010942702 1.177978515625 0.01094792 1.177978515625 0.010947922 1.18408203125 0.01095312 1.18408203125 0.010953122 1.19140625 0.01095834 1.19140625 0.010958342 1.197509765625 0.01096354 1.197509765625 0.010963542 1.20361328125 0.01096876 1.20361328125 0.010968762 1.2109375 0.01097396 1.2109375 0.010973962 1.217041015625 0.01097916 1.217041015625 0.010979162 1.22314453125 0.01098438 1.22314453125 0.010984382 1.23046875 0.01098958 1.23046875 0.010989582 1.236572265625 0.0109948 1.236572265625 0.010994802 1.24267578125 0.011 1.24267578125 0.011000002 1.25 0.0110052 1.25 0.011005202 1.256103515625 0.01101042 1.256103515625 0.011010422 1.26220703125 0.01101562 1.26220703125 0.011015622 1.26953125 0.01102084 1.26953125 0.011020842 1.275634765625 0.01102604 1.275634765625 0.011026042 1.28173828125 0.01103124 1.28173828125 0.011031242 1.2890625 0.01103646 1.2890625 0.011036462 1.295166015625 0.01104166 1.295166015625 0.011041662 1.30126953125 0.01104688 1.30126953125 0.011046882 1.30859375 0.01105208 1.30859375 0.011052082 1.314697265625 0.0110573 1.314697265625 0.011057302 1.32080078125 0.0110625 1.32080078125 0.011062502 1.328125 0.0110677 1.328125 0.011067702 1.334228515625 0.01107292 1.334228515625 0.011072922 1.34033203125 0.01107812 1.34033203125 0.011078122 1.34765625 0.01108334 1.34765625 0.011083342 1.353759765625 0.01108854 1.353759765625 0.011088542 1.35986328125 0.01109376 1.35986328125 0.011093762 1.3671875 0.01109896 1.3671875 0.011098962 1.373291015625 0.01110416 1.373291015625 0.011104162 1.37939453125 0.01110938 1.37939453125 0.011109382 1.38671875 0.01111458 1.38671875 0.011114582 1.392822265625 0.0111198 1.392822265625 0.011119802 1.39892578125 0.011125 1.39892578125 0.011125002 1.40625 0.0111302 1.40625 0.011130202 1.412353515625 0.01113542 1.412353515625 0.011135422 1.41845703125 0.01114062 1.41845703125 0.011140622 1.42578125 0.01114584 1.42578125 0.011145842 1.431884765625 0.01115104 1.431884765625 0.011151042 1.43798828125 0.01115624 1.43798828125 0.011156242 1.4453125 0.01116146 1.4453125 0.011161462 1.451416015625 0.01116666 1.451416015625 0.011166662 1.45751953125 0.01117188 1.45751953125 0.011171882 1.46484375 0.01117708 1.46484375 0.011177082 1.470947265625 0.0111823 1.470947265625 0.011182302 1.47705078125 0.0111875 1.47705078125 0.011187502 1.484375 0.0111927 1.484375 0.011192702 1.490478515625 0.01119792 1.490478515625 0.011197922 1.49658203125 0.01120312 1.49658203125 0.011203122 1.50390625 0.01120834 1.50390625 0.011208342 1.510009765625 0.01121354 1.510009765625 0.011213542 1.51611328125 0.01121876 1.51611328125 0.011218762 1.5234375 0.01122396 1.5234375 0.011223962 1.529541015625 0.01122916 1.529541015625 0.011229162 1.53564453125 0.01123438 1.53564453125 0.011234382 1.54296875 0.01123958 1.54296875 0.011239582 1.549072265625 0.0112448 1.549072265625 0.011244802 1.55517578125 0.01125 1.55517578125 0.011250002 1.5625 0.0112552 1.5625 0.011255202 1.568603515625 0.01126042 1.568603515625 0.011260422 1.57470703125 0.01126562 1.57470703125 0.011265622 1.58203125 0.01127084 1.58203125 0.011270842 1.588134765625 0.01127604 1.588134765625 0.011276042 1.59423828125 0.01128124 1.59423828125 0.011281242 1.6015625 0.01128646 1.6015625 0.011286462 1.607666015625 0.01129166 1.607666015625 0.011291662 1.61376953125 0.01129688 1.61376953125 0.011296882 1.62109375 0.01130208 1.62109375 0.011302082 1.627197265625 0.0113073 1.627197265625 0.011307302 1.63330078125 0.0113125 1.63330078125 0.011312502 1.640625 0.0113177 1.640625 0.011317702 1.646728515625 0.01132292 1.646728515625 0.011322922 1.65283203125 0.01132812 1.65283203125 0.011328122 1.66015625 0.01133334 1.66015625 0.011333342 1.666259765625 0.01133854 1.666259765625 0.011338542 1.67236328125 0.01134376 1.67236328125 0.011343762 1.6796875 0.01134896 1.6796875 0.011348962 1.685791015625 0.01135416 1.685791015625 0.011354162 1.69189453125 0.01135938 1.69189453125 0.011359382 1.69921875 0.01136458 1.69921875 0.011364582 1.705322265625 0.0113698 1.705322265625 0.011369802 1.71142578125 0.011375 1.71142578125 0.011375002 1.71875 0.0113802 1.71875 0.011380202 1.724853515625 0.01138542 1.724853515625 0.011385422 1.73095703125 0.01139062 1.73095703125 0.011390622 1.73828125 0.01139584 1.73828125 0.011395842 1.744384765625 0.01140104 1.744384765625 0.011401042 1.75048828125 0.01140624 1.75048828125 0.011406242 1.7578125 0.01141146 1.7578125 0.011411462 1.763916015625 0.01141666 1.763916015625 0.011416662 1.77001953125 0.01142188 1.77001953125 0.011421882 1.77734375 0.01142708 1.77734375 0.011427082 1.783447265625 0.0114323 1.783447265625 0.011432302 1.78955078125 0.0114375 1.78955078125 0.011437502 1.796875 0.0114427 1.796875 0.011442702 1.802978515625 0.01144792 1.802978515625 0.011447922 1.80908203125 0.01145312 1.80908203125 0.011453122 1.81640625 0.01145834 1.81640625 0.011458342 1.822509765625 0.01146354 1.822509765625 0.011463542 1.82861328125 0.01146876 1.82861328125 0.011468762 1.8359375 0.01147396 1.8359375 0.011473962 1.842041015625 0.01147916 1.842041015625 0.011479162 1.84814453125 0.01148438 1.84814453125 0.011484382 1.85546875 0.01148958 1.85546875 0.011489582 1.861572265625 0.0114948 1.861572265625 0.011494802 1.86767578125 0.0115 1.86767578125 0.011500002 1.875 0.0115052 1.875 0.011505202 1.881103515625 0.01151042 1.881103515625 0.011510422 1.88720703125 0.01151562 1.88720703125 0.011515622 1.89453125 0.01152084 1.89453125 0.011520842 1.900634765625 0.01152604 1.900634765625 0.011526042 1.90673828125 0.01153124 1.90673828125 0.011531242 1.9140625 0.01153646 1.9140625 0.011536462 1.920166015625 0.01154166 1.920166015625 0.011541662 1.92626953125 0.01154688 1.92626953125 0.011546882 1.93359375 0.01155208 1.93359375 0.011552082 1.939697265625 0.0115573 1.939697265625 0.011557302 1.94580078125 0.0115625 1.94580078125 0.011562502 1.953125 0.0115677 1.953125 0.011567702 1.959228515625 0.01157292 1.959228515625 0.011572922 1.96533203125 0.01157812 1.96533203125 0.011578122 1.97265625 0.01158334 1.97265625 0.011583342 1.978759765625 0.01158854 1.978759765625 0.011588542 1.98486328125 0.01159376 1.98486328125 0.011593762 1.9921875 0.01159896 1.9921875 0.011598962 1.998291015625 0.01160416 1.998291015625 0.011604162 2.00439453125 0.01160938 2.00439453125 0.011609382 2.01171875 0.01161458 2.01171875 0.011614582 2.017822265625 0.0116198 2.017822265625 0.011619802 2.02392578125 0.011625 2.02392578125 0.011625002 2.03125 0.0116302 2.03125 0.011630202 2.037353515625 0.01163542 2.037353515625 0.011635422 2.04345703125 0.01164062 2.04345703125 0.011640622 2.05078125 0.01164584 2.05078125 0.011645842 2.056884765625 0.01165104 2.056884765625 0.011651042 2.06298828125 0.01165624 2.06298828125 0.011656242 2.0703125 0.01166146 2.0703125 0.011661462 2.076416015625 0.01166666 2.076416015625 0.011666662 2.08251953125 0.01167188 2.08251953125 0.011671882 2.08984375 0.01167708 2.08984375 0.011677082 2.095947265625 0.0116823 2.095947265625 0.011682302 2.10205078125 0.0116875 2.10205078125 0.011687502 2.109375 0.0116927 2.109375 0.011692702 2.115478515625 0.01169792 2.115478515625 0.011697922 2.12158203125 0.01170312 2.12158203125 0.011703122 2.12890625 0.01170834 2.12890625 0.011708342 2.135009765625 0.01171354 2.135009765625 0.011713542 2.14111328125 0.01171876 2.14111328125 0.011718762 2.1484375 0.01172396 2.1484375 0.011723962 2.154541015625 0.01172916 2.154541015625 0.011729162 2.16064453125 0.01173438 2.16064453125 0.011734382 2.16796875 0.01173958 2.16796875 0.011739582 2.174072265625 0.0117448 2.174072265625 0.011744802 2.18017578125 0.01175 2.18017578125 0.011750002 2.1875 0.0117552 2.1875 0.011755202 2.193603515625 0.01176042 2.193603515625 0.011760422 2.19970703125 0.01176562 2.19970703125 0.011765622 2.20703125 0.01177084 2.20703125 0.011770842 2.213134765625 0.01177604 2.213134765625 0.011776042 2.21923828125 0.01178124 2.21923828125 0.011781242 2.2265625 0.01178646 2.2265625 0.011786462 2.232666015625 0.01179166 2.232666015625 0.011791662 2.23876953125 0.01179688 2.23876953125 0.011796882 2.24609375 0.01180208 2.24609375 0.011802082 2.252197265625 0.0118073 2.252197265625 0.011807302 2.25830078125 0.0118125 2.25830078125 0.011812502 2.265625 0.0118177 2.265625 0.011817702 2.271728515625 0.01182292 2.271728515625 0.011822922 2.27783203125 0.01182812 2.27783203125 0.011828122 2.28515625 0.01183334 2.28515625 0.011833342 2.291259765625 0.01183854 2.291259765625 0.011838542 2.29736328125 0.01184376 2.29736328125 0.011843762 2.3046875 0.01184896 2.3046875 0.011848962 2.310791015625 0.01185416 2.310791015625 0.011854162 2.31689453125 0.01185938 2.31689453125 0.011859382 2.32421875 0.01186458 2.32421875 0.011864582 2.330322265625 0.0118698 2.330322265625 0.011869802 2.33642578125 0.011875 2.33642578125 0.011875002 2.34375 0.0118802 2.34375 0.011880202 2.349853515625 0.01188542 2.349853515625 0.011885422 2.35595703125 0.01189062 2.35595703125 0.011890622 2.36328125 0.01189584 2.36328125 0.011895842 2.369384765625 0.01190104 2.369384765625 0.011901042 2.37548828125 0.01190624 2.37548828125 0.011906242 2.3828125 0.01191146 2.3828125 0.011911462 2.388916015625 0.01191666 2.388916015625 0.011916662 2.39501953125 0.01192188 2.39501953125 0.011921882 2.40234375 0.01192708 2.40234375 0.011927082 2.408447265625 0.0119323 2.408447265625 0.011932302 2.41455078125 0.0119375 2.41455078125 0.011937502 2.421875 0.0119427 2.421875 0.011942702 2.427978515625 0.01194792 2.427978515625 0.011947922 2.43408203125 0.01195312 2.43408203125 0.011953122 2.44140625 0.01195834 2.44140625 0.011958342 2.447509765625 0.01196354 2.447509765625 0.011963542 2.45361328125 0.01196876 2.45361328125 0.011968762 2.4609375 0.01197396 2.4609375 0.011973962 2.467041015625 0.01197916 2.467041015625 0.011979162 2.47314453125 0.01198438 2.47314453125 0.011984382 2.48046875 0.01198958 2.48046875 0.011989582 2.486572265625 0.0119948 2.486572265625 0.011994802 2.49267578125 0.012 2.49267578125 0.012000002 2.5 0.0120052 2.5 0.012005202 2.493896484375 0.01201042 2.493896484375 0.012010422 2.48779296875 0.01201562 2.48779296875 0.012015622 2.481689453125 0.01202084 2.481689453125 0.012020842 2.4755859375 0.01202604 2.4755859375 0.012026042 2.470703125 0.01203124 2.470703125 0.012031242 2.464599609375 0.01203646 2.464599609375 0.012036462 2.459716796875 0.01204166 2.459716796875 0.012041662 2.45361328125 0.01204688 2.45361328125 0.012046882 2.44873046875 0.01205208 2.44873046875 0.012052082 2.44384765625 0.0120573 2.44384765625 0.012057302 2.43896484375 0.0120625 2.43896484375 0.012062502 2.43408203125 0.0120677 2.43408203125 0.012067702 2.430419921875 0.01207292 2.430419921875 0.012072922 2.425537109375 0.01207812 2.425537109375 0.012078122 2.421875 0.01208334 2.421875 0.012083342 2.418212890625 0.01208854 2.418212890625 0.012088542 2.41455078125 0.01209376 2.41455078125 0.012093762 2.412109375 0.01209896 2.412109375 0.012098962 2.408447265625 0.01210416 2.408447265625 0.012104162 2.406005859375 0.01210938 2.406005859375 0.012109382 2.40478515625 0.01211458 2.40478515625 0.012114582 2.40234375 0.0121198 2.40234375 0.012119802 2.401123046875 0.012125 2.401123046875 0.012125002 2.39990234375 0.0121302 2.39990234375 0.012130202 2.398681640625 0.01214584 2.398681640625 0.012145842 2.39990234375 0.01215624 2.39990234375 0.012156242 2.40234375 0.01216146 2.40234375 0.012161462 2.403564453125 0.01216666 2.403564453125 0.012166662 2.406005859375 0.01217188 2.406005859375 0.012171882 2.408447265625 0.01217708 2.408447265625 0.012177082 2.410888671875 0.0121823 2.410888671875 0.012182302 2.41455078125 0.0121875 2.41455078125 0.012187502 2.418212890625 0.0121927 2.418212890625 0.012192702 2.423095703125 0.01219792 2.423095703125 0.012197922 2.427978515625 0.01220312 2.427978515625 0.012203122 2.432861328125 0.01220834 2.432861328125 0.012208342 2.43896484375 0.01221354 2.43896484375 0.012213542 2.445068359375 0.01221876 2.445068359375 0.012218762 2.451171875 0.01222396 2.451171875 0.012223962 2.45849609375 0.01222916 2.45849609375 0.012229162 2.4658203125 0.01223438 2.4658203125 0.012234382 2.47314453125 0.01223958 2.47314453125 0.012239582 2.481689453125 0.0122448 2.481689453125 0.012244802 2.490234375 0.01225 2.490234375 0.012250002 2.498779296875 0.0122552 2.498779296875 0.012255202 2.508544921875 0.01226042 2.508544921875 0.012260422 2.518310546875 0.01226562 2.518310546875 0.012265622 2.528076171875 0.01227084 2.528076171875 0.012270842 2.5390625 0.01227604 2.5390625 0.012276042 2.550048828125 0.01228124 2.550048828125 0.012281242 2.56103515625 0.01228646 2.56103515625 0.012286462 2.572021484375 0.01229166 2.572021484375 0.012291662 2.584228515625 0.01229688 2.584228515625 0.012296882 2.596435546875 0.01230208 2.596435546875 0.012302082 2.608642578125 0.0123073 2.608642578125 0.012307302 2.620849609375 0.0123125 2.620849609375 0.012312502 2.63427734375 0.0123177 2.63427734375 0.012317702 2.646484375 0.01232292 2.646484375 0.012322922 2.659912109375 0.01232812 2.659912109375 0.012328122 2.67333984375 0.01233334 2.67333984375 0.012333342 2.686767578125 0.01233854 2.686767578125 0.012338542 2.7001953125 0.01234376 2.7001953125 0.012343762 2.713623046875 0.01234896 2.713623046875 0.012348962 2.728271484375 0.01235416 2.728271484375 0.012354162 2.74169921875 0.01235938 2.74169921875 0.012359382 2.75634765625 0.01236458 2.75634765625 0.012364582 2.769775390625 0.0123698 2.769775390625 0.012369802 2.783203125 0.012375 2.783203125 0.012375002 2.7978515625 0.0123802 2.7978515625 0.012380202 2.811279296875 0.01238542 2.811279296875 0.012385422 2.82470703125 0.01239062 2.82470703125 0.012390622 2.83935546875 0.01239584 2.83935546875 0.012395842 2.852783203125 0.01240104 2.852783203125 0.012401042 2.8662109375 0.01240624 2.8662109375 0.012406242 2.879638671875 0.01241146 2.879638671875 0.012411462 2.891845703125 0.01241666 2.891845703125 0.012416662 2.9052734375 0.01242188 2.9052734375 0.012421882 2.91748046875 0.01242708 2.91748046875 0.012427082 2.9296875 0.0124323 2.9296875 0.012432302 2.94189453125 0.0124375 2.94189453125 0.012437502 2.9541015625 0.0124427 2.9541015625 0.012442702 2.965087890625 0.01244792 2.965087890625 0.012447922 2.97607421875 0.01245312 2.97607421875 0.012453122 2.987060546875 0.01245834 2.987060546875 0.012458342 2.996826171875 0.01246354 2.996826171875 0.012463542 3.006591796875 0.01246876 3.006591796875 0.012468762 3.016357421875 0.01247396 3.016357421875 0.012473962 3.02490234375 0.01247916 3.02490234375 0.012479162 3.033447265625 0.01248438 3.033447265625 0.012484382 3.0419921875 0.01248958 3.0419921875 0.012489582 3.04931640625 0.0124948 3.04931640625 0.012494802 3.055419921875 0.0125 3.055419921875 0.012500002 3.0615234375 0.0125052 3.0615234375 0.012505202 3.067626953125 0.01251042 3.067626953125 0.012510422 3.072509765625 0.01251562 3.072509765625 0.012515622 3.076171875 0.01252084 3.076171875 0.012520842 3.079833984375 0.01252604 3.079833984375 0.012526042 3.08349609375 0.01253124 3.08349609375 0.012531242 3.0859375 0.01253646 3.0859375 0.012536462 3.087158203125 0.01254166 3.087158203125 0.012541662 3.08837890625 0.01255208 3.08837890625 0.012552082 3.087158203125 0.0125573 3.087158203125 0.012557302 3.0859375 0.0125625 3.0859375 0.012562502 3.08349609375 0.0125677 3.08349609375 0.012567702 3.0810546875 0.01257292 3.0810546875 0.012572922 3.077392578125 0.01257812 3.077392578125 0.012578122 3.072509765625 0.01258334 3.072509765625 0.012583342 3.067626953125 0.01258854 3.067626953125 0.012588542 3.0615234375 0.01259376 3.0615234375 0.012593762 3.05419921875 0.01259896 3.05419921875 0.012598962 3.046875 0.01260416 3.046875 0.012604162 3.038330078125 0.01260938 3.038330078125 0.012609382 3.02978515625 0.01261458 3.02978515625 0.012614582 3.018798828125 0.0126198 3.018798828125 0.012619802 3.0078125 0.012625 3.0078125 0.012625002 2.996826171875 0.0126302 2.996826171875 0.012630202 2.9833984375 0.01263542 2.9833984375 0.012635422 2.97119140625 0.01264062 2.97119140625 0.012640622 2.95654296875 0.01264584 2.95654296875 0.012645842 2.94189453125 0.01265104 2.94189453125 0.012651042 2.926025390625 0.01265624 2.926025390625 0.012656242 2.908935546875 0.01266146 2.908935546875 0.012661462 2.891845703125 0.01266666 2.891845703125 0.012666662 2.874755859375 0.01267188 2.874755859375 0.012671882 2.855224609375 0.01267708 2.855224609375 0.012677082 2.835693359375 0.0126823 2.835693359375 0.012682302 2.816162109375 0.0126875 2.816162109375 0.012687502 2.79541015625 0.0126927 2.79541015625 0.012692702 2.7734375 0.01269792 2.7734375 0.012697922 2.75146484375 0.01270312 2.75146484375 0.012703122 2.7294921875 0.01270834 2.7294921875 0.012708342 2.705078125 0.01271354 2.705078125 0.012713542 2.681884765625 0.01271876 2.681884765625 0.012718762 2.657470703125 0.01272396 2.657470703125 0.012723962 2.6318359375 0.01272916 2.6318359375 0.012729162 2.606201171875 0.01273438 2.606201171875 0.012734382 2.58056640625 0.01273958 2.58056640625 0.012739582 2.5537109375 0.0127448 2.5537109375 0.012744802 2.52685546875 0.01275 2.52685546875 0.012750002 2.5 0.0127552 2.5 0.012755202 2.471923828125 0.01276042 2.471923828125 0.012760422 2.44384765625 0.01276562 2.44384765625 0.012765622 2.41455078125 0.01277084 2.41455078125 0.012770842 2.386474609375 0.01277604 2.386474609375 0.012776042 2.357177734375 0.01278124 2.357177734375 0.012781242 2.327880859375 0.01278646 2.327880859375 0.012786462 2.298583984375 0.01279166 2.298583984375 0.012791662 2.269287109375 0.01279688 2.269287109375 0.012796882 2.23876953125 0.01280208 2.23876953125 0.012802082 2.20947265625 0.0128073 2.20947265625 0.012807302 2.178955078125 0.0128125 2.178955078125 0.012812502 2.149658203125 0.0128177 2.149658203125 0.012817702 2.120361328125 0.01282292 2.120361328125 0.012822922 2.08984375 0.01282812 2.08984375 0.012828122 2.060546875 0.01283334 2.060546875 0.012833342 2.03125 0.01283854 2.03125 0.012838542 2.001953125 0.01284376 2.001953125 0.012843762 1.97265625 0.01284896 1.97265625 0.012848962 1.943359375 0.01285416 1.943359375 0.012854162 1.9140625 0.01285938 1.9140625 0.012859382 1.885986328125 0.01286458 1.885986328125 0.012864582 1.85791015625 0.0128698 1.85791015625 0.012869802 1.8310546875 0.012875 1.8310546875 0.012875002 1.802978515625 0.0128802 1.802978515625 0.012880202 1.77734375 0.01288542 1.77734375 0.012885422 1.75048828125 0.01289062 1.75048828125 0.012890622 1.724853515625 0.01289584 1.724853515625 0.012895842 1.700439453125 0.01290104 1.700439453125 0.012901042 1.676025390625 0.01290624 1.676025390625 0.012906242 1.651611328125 0.01291146 1.651611328125 0.012911462 1.62841796875 0.01291666 1.62841796875 0.012916662 1.6064453125 0.01292188 1.6064453125 0.012921882 1.58447265625 0.01292708 1.58447265625 0.012927082 1.563720703125 0.0129323 1.563720703125 0.012932302 1.544189453125 0.0129375 1.544189453125 0.012937502 1.524658203125 0.0129427 1.524658203125 0.012942702 1.507568359375 0.01294792 1.507568359375 0.012947922 1.4892578125 0.01295312 1.4892578125 0.012953122 1.473388671875 0.01295834 1.473388671875 0.012958342 1.458740234375 0.01296354 1.458740234375 0.012963542 1.444091796875 0.01296876 1.444091796875 0.012968762 1.4306640625 0.01297396 1.4306640625 0.012973962 1.41845703125 0.01297916 1.41845703125 0.012979162 1.407470703125 0.01298438 1.407470703125 0.012984382 1.397705078125 0.01298958 1.397705078125 0.012989582 1.38916015625 0.0129948 1.38916015625 0.012994802 1.380615234375 0.013 1.380615234375 0.013000002 1.37451171875 0.0130052 1.37451171875 0.013005202 1.36962890625 0.01301042 1.36962890625 0.013010422 1.365966796875 0.01301562 1.365966796875 0.013015622 1.3623046875 0.01302084 1.3623046875 0.013020842 1.361083984375 0.01303124 1.361083984375 0.013031242 1.3623046875 0.01303646 1.3623046875 0.013036462 1.363525390625 0.01304166 1.363525390625 0.013041662 1.3671875 0.01304688 1.3671875 0.013046882 1.3720703125 0.01305208 1.3720703125 0.013052082 1.37939453125 0.0130573 1.37939453125 0.013057302 1.38671875 0.0130625 1.38671875 0.013062502 1.395263671875 0.0130677 1.395263671875 0.013067702 1.405029296875 0.01307292 1.405029296875 0.013072922 1.417236328125 0.01307812 1.417236328125 0.013078122 1.429443359375 0.01308334 1.429443359375 0.013083342 1.444091796875 0.01308854 1.444091796875 0.013088542 1.4599609375 0.01309376 1.4599609375 0.013093762 1.47705078125 0.01309896 1.47705078125 0.013098962 1.494140625 0.01310416 1.494140625 0.013104162 1.513671875 0.01310938 1.513671875 0.013109382 1.534423828125 0.01311458 1.534423828125 0.013114582 1.556396484375 0.0131198 1.556396484375 0.013119802 1.57958984375 0.013125 1.57958984375 0.013125002 1.605224609375 0.0131302 1.605224609375 0.013130202 1.630859375 0.01313542 1.630859375 0.013135422 1.65771484375 0.01314062 1.65771484375 0.013140622 1.685791015625 0.01314584 1.685791015625 0.013145842 1.715087890625 0.01315104 1.715087890625 0.013151042 1.74560546875 0.01315624 1.74560546875 0.013156242 1.77734375 0.01316146 1.77734375 0.013161462 1.80908203125 0.01316666 1.80908203125 0.013166662 1.84326171875 0.01317188 1.84326171875 0.013171882 1.878662109375 0.01317708 1.878662109375 0.013177082 1.9140625 0.0131823 1.9140625 0.013182302 1.95068359375 0.0131875 1.95068359375 0.013187502 1.988525390625 0.0131927 1.988525390625 0.013192702 2.0263671875 0.01319792 2.0263671875 0.013197922 2.066650390625 0.01320312 2.066650390625 0.013203122 2.10693359375 0.01320834 2.10693359375 0.013208342 2.147216796875 0.01321354 2.147216796875 0.013213542 2.18994140625 0.01321876 2.18994140625 0.013218762 2.2314453125 0.01322396 2.2314453125 0.013223962 2.275390625 0.01322916 2.275390625 0.013229162 2.3193359375 0.01323438 2.3193359375 0.013234382 2.36328125 0.01323958 2.36328125 0.013239582 2.408447265625 0.0132448 2.408447265625 0.013244802 2.45361328125 0.01325 2.45361328125 0.013250002 2.498779296875 0.0132552 2.498779296875 0.013255202 2.545166015625 0.01326042 2.545166015625 0.013260422 2.591552734375 0.01326562 2.591552734375 0.013265622 2.63916015625 0.01327084 2.63916015625 0.013270842 2.685546875 0.01327604 2.685546875 0.013276042 2.733154296875 0.01328124 2.733154296875 0.013281242 2.78076171875 0.01328646 2.78076171875 0.013286462 2.828369140625 0.01329166 2.828369140625 0.013291662 2.874755859375 0.01329688 2.874755859375 0.013296882 2.92236328125 0.01330208 2.92236328125 0.013302082 2.969970703125 0.0133073 2.969970703125 0.013307302 3.017578125 0.0133125 3.017578125 0.013312502 3.06396484375 0.0133177 3.06396484375 0.013317702 3.111572265625 0.01332292 3.111572265625 0.013322922 3.157958984375 0.01332812 3.157958984375 0.013328122 3.203125 0.01333334 3.203125 0.013333342 3.24951171875 0.01333854 3.24951171875 0.013338542 3.294677734375 0.01334376 3.294677734375 0.013343762 3.338623046875 0.01334896 3.338623046875 0.013348962 3.382568359375 0.01335416 3.382568359375 0.013354162 3.426513671875 0.01335938 3.426513671875 0.013359382 3.46923828125 0.01336458 3.46923828125 0.013364582 3.5107421875 0.0133698 3.5107421875 0.013369802 3.55224609375 0.013375 3.55224609375 0.013375002 3.592529296875 0.0133802 3.592529296875 0.013380202 3.6328125 0.01338542 3.6328125 0.013385422 3.670654296875 0.01339062 3.670654296875 0.013390622 3.70849609375 0.01339584 3.70849609375 0.013395842 3.7451171875 0.01340104 3.7451171875 0.013401042 3.780517578125 0.01340624 3.780517578125 0.013406242 3.814697265625 0.01341146 3.814697265625 0.013411462 3.84765625 0.01341666 3.84765625 0.013416662 3.87939453125 0.01342188 3.87939453125 0.013421882 3.909912109375 0.01342708 3.909912109375 0.013427082 3.939208984375 0.0134323 3.939208984375 0.013432302 3.96728515625 0.0134375 3.96728515625 0.013437502 3.992919921875 0.0134427 3.992919921875 0.013442702 4.0185546875 0.01344792 4.0185546875 0.013447922 4.041748046875 0.01345312 4.041748046875 0.013453122 4.063720703125 0.01345834 4.063720703125 0.013458342 4.083251953125 0.01346354 4.083251953125 0.013463542 4.102783203125 0.01346876 4.102783203125 0.013468762 4.119873046875 0.01347396 4.119873046875 0.013473962 4.134521484375 0.01347916 4.134521484375 0.013479162 4.149169921875 0.01348438 4.149169921875 0.013484382 4.161376953125 0.01348958 4.161376953125 0.013489582 4.171142578125 0.0134948 4.171142578125 0.013494802 4.1796875 0.0135 4.1796875 0.013500002 4.18701171875 0.0135052 4.18701171875 0.013505202 4.19189453125 0.01351042 4.19189453125 0.013510422 4.1943359375 0.01351562 4.1943359375 0.013515622 4.195556640625 0.01352604 4.195556640625 0.013526042 4.193115234375 0.01353124 4.193115234375 0.013531242 4.188232421875 0.01353646 4.188232421875 0.013536462 4.18212890625 0.01354166 4.18212890625 0.013541662 4.1748046875 0.01354688 4.1748046875 0.013546882 4.163818359375 0.01355208 4.163818359375 0.013552082 4.15283203125 0.0135573 4.15283203125 0.013557302 4.13818359375 0.0135625 4.13818359375 0.013562502 4.12353515625 0.0135677 4.12353515625 0.013567702 4.105224609375 0.01357292 4.105224609375 0.013572922 4.085693359375 0.01357812 4.085693359375 0.013578122 4.06494140625 0.01358334 4.06494140625 0.013583342 4.041748046875 0.01358854 4.041748046875 0.013588542 4.01611328125 0.01359376 4.01611328125 0.013593762 3.9892578125 0.01359896 3.9892578125 0.013598962 3.961181640625 0.01360416 3.961181640625 0.013604162 3.9306640625 0.01360938 3.9306640625 0.013609382 3.89892578125 0.01361458 3.89892578125 0.013614582 3.86474609375 0.0136198 3.86474609375 0.013619802 3.829345703125 0.013625 3.829345703125 0.013625002 3.79150390625 0.0136302 3.79150390625 0.013630202 3.75244140625 0.01363542 3.75244140625 0.013635422 3.712158203125 0.01364062 3.712158203125 0.013640622 3.670654296875 0.01364584 3.670654296875 0.013645842 3.626708984375 0.01365104 3.626708984375 0.013651042 3.58154296875 0.01365624 3.58154296875 0.013656242 3.533935546875 0.01366146 3.533935546875 0.013661462 3.486328125 0.01366666 3.486328125 0.013666662 3.436279296875 0.01367188 3.436279296875 0.013671882 3.38623046875 0.01367708 3.38623046875 0.013677082 3.333740234375 0.0136823 3.333740234375 0.013682302 3.280029296875 0.0136875 3.280029296875 0.013687502 3.226318359375 0.0136927 3.226318359375 0.013692702 3.170166015625 0.01369792 3.170166015625 0.013697922 3.11279296875 0.01370312 3.11279296875 0.013703122 3.055419921875 0.01370834 3.055419921875 0.013708342 2.996826171875 0.01371354 2.996826171875 0.013713542 2.93701171875 0.01371876 2.93701171875 0.013718762 2.8759765625 0.01372396 2.8759765625 0.013723962 2.81494140625 0.01372916 2.81494140625 0.013729162 2.75390625 0.01373438 2.75390625 0.013734382 2.6904296875 0.01373958 2.6904296875 0.013739582 2.626953125 0.0137448 2.626953125 0.013744802 2.5634765625 0.01375 2.5634765625 0.013750002 2.5 0.0137552 2.5 0.013755202 2.435302734375 0.01376042 2.435302734375 0.013760422 2.369384765625 0.01376562 2.369384765625 0.013765622 2.3046875 0.01377084 2.3046875 0.013770842 2.23876953125 0.01377604 2.23876953125 0.013776042 2.174072265625 0.01378124 2.174072265625 0.013781242 2.108154296875 0.01378646 2.108154296875 0.013786462 2.04345703125 0.01379166 2.04345703125 0.013791662 1.9775390625 0.01379688 1.9775390625 0.013796882 1.912841796875 0.01380208 1.912841796875 0.013802082 1.84814453125 0.0138073 1.84814453125 0.013807302 1.783447265625 0.0138125 1.783447265625 0.013812502 1.71875 0.0138177 1.71875 0.013817702 1.6552734375 0.01382292 1.6552734375 0.013822922 1.593017578125 0.01382812 1.593017578125 0.013828122 1.53076171875 0.01383334 1.53076171875 0.013833342 1.468505859375 0.01383854 1.468505859375 0.013838542 1.407470703125 0.01384376 1.407470703125 0.013843762 1.34765625 0.01384896 1.34765625 0.013848962 1.287841796875 0.01385416 1.287841796875 0.013854162 1.23046875 0.01385938 1.23046875 0.013859382 1.173095703125 0.01386458 1.173095703125 0.013864582 1.116943359375 0.0138698 1.116943359375 0.013869802 1.06201171875 0.013875 1.06201171875 0.013875002 1.00830078125 0.0138802 1.00830078125 0.013880202 0.955810546875 0.01388542 0.955810546875 0.013885422 0.904541015625 0.01389062 0.904541015625 0.013890622 0.855712890625 0.01389584 0.855712890625 0.013895842 0.80810546875 0.01390104 0.80810546875 0.013901042 0.76171875 0.01390624 0.76171875 0.013906242 0.716552734375 0.01391146 0.716552734375 0.013911462 0.673828125 0.01391666 0.673828125 0.013916662 0.63232421875 0.01392188 0.63232421875 0.013921882 0.59326171875 0.01392708 0.59326171875 0.013927082 0.555419921875 0.0139323 0.555419921875 0.013932302 0.52001953125 0.0139375 0.52001953125 0.013937502 0.48583984375 0.0139427 0.48583984375 0.013942702 0.4541015625 0.01394792 0.4541015625 0.013947922 0.4248046875 0.01395312 0.4248046875 0.013953122 0.396728515625 0.01395834 0.396728515625 0.013958342 0.372314453125 0.01396354 0.372314453125 0.013963542 0.34912109375 0.01396876 0.34912109375 0.013968762 0.3271484375 0.01397396 0.3271484375 0.013973962 0.308837890625 0.01397916 0.308837890625 0.013979162 0.29296875 0.01398438 0.29296875 0.013984382 0.2783203125 0.01398958 0.2783203125 0.013989582 0.26611328125 0.0139948 0.26611328125 0.013994802 0.257568359375 0.014 0.257568359375 0.014000002 0.250244140625 0.0140052 0.250244140625 0.014005202 0.25146484375 0.01401042 0.25146484375 0.014010422 0.255126953125 0.01401562 0.255126953125 0.014015622 0.26123046875 0.01402084 0.26123046875 0.014020842 0.269775390625 0.01402604 0.269775390625 0.014026042 0.279541015625 0.01403124 0.279541015625 0.014031242 0.29296875 0.01403646 0.29296875 0.014036462 0.308837890625 0.01404166 0.308837890625 0.014041662 0.3271484375 0.01404688 0.3271484375 0.014046882 0.3466796875 0.01405208 0.3466796875 0.014052082 0.369873046875 0.0140573 0.369873046875 0.014057302 0.394287109375 0.0140625 0.394287109375 0.014062502 0.421142578125 0.0140677 0.421142578125 0.014067702 0.450439453125 0.01407292 0.450439453125 0.014072922 0.482177734375 0.01407812 0.482177734375 0.014078122 0.51513671875 0.01408334 0.51513671875 0.014083342 0.5517578125 0.01408854 0.5517578125 0.014088542 0.589599609375 0.01409376 0.589599609375 0.014093762 0.628662109375 0.01409896 0.628662109375 0.014098962 0.67138671875 0.01410416 0.67138671875 0.014104162 0.71533203125 0.01410938 0.71533203125 0.014109382 0.760498046875 0.01411458 0.760498046875 0.014114582 0.80810546875 0.0141198 0.80810546875 0.014119802 0.858154296875 0.014125 0.858154296875 0.014125002 0.908203125 0.0141302 0.908203125 0.014130202 0.9619140625 0.01413542 0.9619140625 0.014135422 1.016845703125 0.01414062 1.016845703125 0.014140622 1.07177734375 0.01414584 1.07177734375 0.014145842 1.13037109375 0.01415104 1.13037109375 0.014151042 1.18896484375 0.01415624 1.18896484375 0.014156242 1.25 0.01416146 1.25 0.014161462 1.31103515625 0.01416666 1.31103515625 0.014166662 1.37451171875 0.01417188 1.37451171875 0.014171882 1.439208984375 0.01417708 1.439208984375 0.014177082 1.50390625 0.0141823 1.50390625 0.014182302 1.571044921875 0.0141875 1.571044921875 0.014187502 1.63818359375 0.0141927 1.63818359375 0.014192702 1.70654296875 0.01419792 1.70654296875 0.014197922 1.776123046875 0.01420312 1.776123046875 0.014203122 1.846923828125 0.01420834 1.846923828125 0.014208342 1.917724609375 0.01421354 1.917724609375 0.014213542 1.988525390625 0.01421876 1.988525390625 0.014218762 2.060546875 0.01422396 2.060546875 0.014223962 2.132568359375 0.01422916 2.132568359375 0.014229162 2.205810546875 0.01423438 2.205810546875 0.014234382 2.279052734375 0.01423958 2.279052734375 0.014239582 2.352294921875 0.0142448 2.352294921875 0.014244802 2.425537109375 0.01425 2.425537109375 0.014250002 2.498779296875 0.0142552 2.498779296875 0.014255202 2.5732421875 0.01426042 2.5732421875 0.014260422 2.646484375 0.01426562 2.646484375 0.014265622 2.7197265625 0.01427084 2.7197265625 0.014270842 2.79296875 0.01427604 2.79296875 0.014276042 2.8662109375 0.01428124 2.8662109375 0.014281242 2.938232421875 0.01428646 2.938232421875 0.014286462 3.01025390625 0.01429166 3.01025390625 0.014291662 3.0810546875 0.01429688 3.0810546875 0.014296882 3.15185546875 0.01430208 3.15185546875 0.014302082 3.22265625 0.0143073 3.22265625 0.014307302 3.292236328125 0.0143125 3.292236328125 0.014312502 3.360595703125 0.0143177 3.360595703125 0.014317702 3.427734375 0.01432292 3.427734375 0.014322922 3.494873046875 0.01432812 3.494873046875 0.014328122 3.5595703125 0.01433334 3.5595703125 0.014333342 3.624267578125 0.01433854 3.624267578125 0.014338542 3.687744140625 0.01434376 3.687744140625 0.014343762 3.748779296875 0.01434896 3.748779296875 0.014348962 3.809814453125 0.01435416 3.809814453125 0.014354162 3.868408203125 0.01435938 3.868408203125 0.014359382 3.927001953125 0.01436458 3.927001953125 0.014364582 3.98193359375 0.0143698 3.98193359375 0.014369802 4.036865234375 0.014375 4.036865234375 0.014375002 4.090576171875 0.0143802 4.090576171875 0.014380202 4.140625 0.01438542 4.140625 0.014385422 4.190673828125 0.01439062 4.190673828125 0.014390622 4.23828125 0.01439584 4.23828125 0.014395842 4.283447265625 0.01440104 4.283447265625 0.014401042 4.327392578125 0.01440624 4.327392578125 0.014406242 4.3701171875 0.01441146 4.3701171875 0.014411462 4.4091796875 0.01441666 4.4091796875 0.014416662 4.447021484375 0.01442188 4.447021484375 0.014421882 4.483642578125 0.01442708 4.483642578125 0.014427082 4.5166015625 0.0144323 4.5166015625 0.014432302 4.54833984375 0.0144375 4.54833984375 0.014437502 4.57763671875 0.0144427 4.57763671875 0.014442702 4.6044921875 0.01444792 4.6044921875 0.014447922 4.62890625 0.01445312 4.62890625 0.014453122 4.652099609375 0.01445834 4.652099609375 0.014458342 4.671630859375 0.01446354 4.671630859375 0.014463542 4.68994140625 0.01446876 4.68994140625 0.014468762 4.705810546875 0.01447396 4.705810546875 0.014473962 4.71923828125 0.01447916 4.71923828125 0.014479162 4.72900390625 0.01448438 4.72900390625 0.014484382 4.737548828125 0.01448958 4.737548828125 0.014489582 4.74365234375 0.0144948 4.74365234375 0.014494802 4.747314453125 0.0145 4.747314453125 0.014500002 4.74853515625 0.0145052 4.74853515625 0.014505202 4.747314453125 0.01451042 4.747314453125 0.014510422 4.74365234375 0.01451562 4.74365234375 0.014515622 4.737548828125 0.01452084 4.737548828125 0.014520842 4.72900390625 0.01452604 4.72900390625 0.014526042 4.71923828125 0.01453124 4.71923828125 0.014531242 4.705810546875 0.01453646 4.705810546875 0.014536462 4.68994140625 0.01454166 4.68994140625 0.014541662 4.671630859375 0.01454688 4.671630859375 0.014546882 4.652099609375 0.01455208 4.652099609375 0.014552082 4.62890625 0.0145573 4.62890625 0.014557302 4.6044921875 0.0145625 4.6044921875 0.014562502 4.57763671875 0.0145677 4.57763671875 0.014567702 4.54833984375 0.01457292 4.54833984375 0.014572922 4.5166015625 0.01457812 4.5166015625 0.014578122 4.483642578125 0.01458334 4.483642578125 0.014583342 4.447021484375 0.01458854 4.447021484375 0.014588542 4.4091796875 0.01459376 4.4091796875 0.014593762 4.3701171875 0.01459896 4.3701171875 0.014598962 4.327392578125 0.01460416 4.327392578125 0.014604162 4.283447265625 0.01460938 4.283447265625 0.014609382 4.23828125 0.01461458 4.23828125 0.014614582 4.190673828125 0.0146198 4.190673828125 0.014619802 4.140625 0.014625 4.140625 0.014625002 4.090576171875 0.0146302 4.090576171875 0.014630202 4.036865234375 0.01463542 4.036865234375 0.014635422 3.98193359375 0.01464062 3.98193359375 0.014640622 3.927001953125 0.01464584 3.927001953125 0.014645842 3.868408203125 0.01465104 3.868408203125 0.014651042 3.809814453125 0.01465624 3.809814453125 0.014656242 3.748779296875 0.01466146 3.748779296875 0.014661462 3.687744140625 0.01466666 3.687744140625 0.014666662 3.624267578125 0.01467188 3.624267578125 0.014671882 3.5595703125 0.01467708 3.5595703125 0.014677082 3.494873046875 0.0146823 3.494873046875 0.014682302 3.427734375 0.0146875 3.427734375 0.014687502 3.360595703125 0.0146927 3.360595703125 0.014692702 3.292236328125 0.01469792 3.292236328125 0.014697922 3.22265625 0.01470312 3.22265625 0.014703122 3.15185546875 0.01470834 3.15185546875 0.014708342 3.0810546875 0.01471354 3.0810546875 0.014713542 3.01025390625 0.01471876 3.01025390625 0.014718762 2.938232421875 0.01472396 2.938232421875 0.014723962 2.8662109375 0.01472916 2.8662109375 0.014729162 2.79296875 0.01473438 2.79296875 0.014734382 2.7197265625 0.01473958 2.7197265625 0.014739582 2.646484375 0.0147448 2.646484375 0.014744802 2.5732421875 0.01475 2.5732421875 0.014750002 2.5 0.0147552 2.5 0.014755202 2.425537109375 0.01476042 2.425537109375 0.014760422 2.352294921875 0.01476562 2.352294921875 0.014765622 2.279052734375 0.01477084 2.279052734375 0.014770842 2.205810546875 0.01477604 2.205810546875 0.014776042 2.132568359375 0.01478124 2.132568359375 0.014781242 2.060546875 0.01478646 2.060546875 0.014786462 1.988525390625 0.01479166 1.988525390625 0.014791662 1.917724609375 0.01479688 1.917724609375 0.014796882 1.846923828125 0.01480208 1.846923828125 0.014802082 1.776123046875 0.0148073 1.776123046875 0.014807302 1.70654296875 0.0148125 1.70654296875 0.014812502 1.63818359375 0.0148177 1.63818359375 0.014817702 1.571044921875 0.01482292 1.571044921875 0.014822922 1.50390625 0.01482812 1.50390625 0.014828122 1.439208984375 0.01483334 1.439208984375 0.014833342 1.37451171875 0.01483854 1.37451171875 0.014838542 1.31103515625 0.01484376 1.31103515625 0.014843762 1.25 0.01484896 1.25 0.014848962 1.18896484375 0.01485416 1.18896484375 0.014854162 1.13037109375 0.01485938 1.13037109375 0.014859382 1.07177734375 0.01486458 1.07177734375 0.014864582 1.016845703125 0.0148698 1.016845703125 0.014869802 0.9619140625 0.014875 0.9619140625 0.014875002 0.908203125 0.0148802 0.908203125 0.014880202 0.858154296875 0.01488542 0.858154296875 0.014885422 0.80810546875 0.01489062 0.80810546875 0.014890622 0.760498046875 0.01489584 0.760498046875 0.014895842 0.71533203125 0.01490104 0.71533203125 0.014901042 0.67138671875 0.01490624 0.67138671875 0.014906242 0.628662109375 0.01491146 0.628662109375 0.014911462 0.589599609375 0.01491666 0.589599609375 0.014916662 0.5517578125 0.01492188 0.5517578125 0.014921882 0.51513671875 0.01492708 0.51513671875 0.014927082 0.482177734375 0.0149323 0.482177734375 0.014932302 0.450439453125 0.0149375 0.450439453125 0.014937502 0.421142578125 0.0149427 0.421142578125 0.014942702 0.394287109375 0.01494792 0.394287109375 0.014947922 0.369873046875 0.01495312 0.369873046875 0.014953122 0.3466796875 0.01495834 0.3466796875 0.014958342 0.3271484375 0.01496354 0.3271484375 0.014963542 0.308837890625 0.01496876 0.308837890625 0.014968762 0.29296875 0.01497396 0.29296875 0.014973962 0.279541015625 0.01497916 0.279541015625 0.014979162 0.269775390625 0.01498438 0.269775390625 0.014984382 0.26123046875 0.01498958 0.26123046875 0.014989582 0.255126953125 0.0149948 0.255126953125 0.014994802 0.25146484375 0.015 0.25146484375 0.015000002 0.250244140625 0.0150052 0.250244140625 0.015005202 0.25146484375 0.01501042 0.25146484375 0.015010422 0.255126953125 0.01501562 0.255126953125 0.015015622 0.26123046875 0.01502084 0.26123046875 0.015020842 0.269775390625 0.01502604 0.269775390625 0.015026042 0.279541015625 0.01503124 0.279541015625 0.015031242 0.29296875 0.01503646 0.29296875 0.015036462 0.308837890625 0.01504166 0.308837890625 0.015041662 0.3271484375 0.01504688 0.3271484375 0.015046882 0.3466796875 0.01505208 0.3466796875 0.015052082 0.369873046875 0.0150573 0.369873046875 0.015057302 0.394287109375 0.0150625 0.394287109375 0.015062502 0.421142578125 0.0150677 0.421142578125 0.015067702 0.450439453125 0.01507292 0.450439453125 0.015072922 0.482177734375 0.01507812 0.482177734375 0.015078122 0.51513671875 0.01508334 0.51513671875 0.015083342 0.5517578125 0.01508854 0.5517578125 0.015088542 0.589599609375 0.01509376 0.589599609375 0.015093762 0.628662109375 0.01509896 0.628662109375 0.015098962 0.67138671875 0.01510416 0.67138671875 0.015104162 0.71533203125 0.01510938 0.71533203125 0.015109382 0.760498046875 0.01511458 0.760498046875 0.015114582 0.80810546875 0.0151198 0.80810546875 0.015119802 0.858154296875 0.015125 0.858154296875 0.015125002 0.908203125 0.0151302 0.908203125 0.015130202 0.9619140625 0.01513542 0.9619140625 0.015135422 1.016845703125 0.01514062 1.016845703125 0.015140622 1.07177734375 0.01514584 1.07177734375 0.015145842 1.13037109375 0.01515104 1.13037109375 0.015151042 1.18896484375 0.01515624 1.18896484375 0.015156242 1.25 0.01516146 1.25 0.015161462 1.31103515625 0.01516666 1.31103515625 0.015166662 1.37451171875 0.01517188 1.37451171875 0.015171882 1.439208984375 0.01517708 1.439208984375 0.015177082 1.50390625 0.0151823 1.50390625 0.015182302 1.571044921875 0.0151875 1.571044921875 0.015187502 1.63818359375 0.0151927 1.63818359375 0.015192702 1.70654296875 0.01519792 1.70654296875 0.015197922 1.776123046875 0.01520312 1.776123046875 0.015203122 1.846923828125 0.01520834 1.846923828125 0.015208342 1.917724609375 0.01521354 1.917724609375 0.015213542 1.988525390625 0.01521876 1.988525390625 0.015218762 2.060546875 0.01522396 2.060546875 0.015223962 2.132568359375 0.01522916 2.132568359375 0.015229162 2.205810546875 0.01523438 2.205810546875 0.015234382 2.279052734375 0.01523958 2.279052734375 0.015239582 2.352294921875 0.0152448 2.352294921875 0.015244802 2.425537109375 0.01525 2.425537109375 0.015250002 2.498779296875 0.0152552 2.498779296875 0.015255202 2.5732421875 0.01526042 2.5732421875 0.015260422 2.646484375 0.01526562 2.646484375 0.015265622 2.7197265625 0.01527084 2.7197265625 0.015270842 2.79296875 0.01527604 2.79296875 0.015276042 2.8662109375 0.01528124 2.8662109375 0.015281242 2.938232421875 0.01528646 2.938232421875 0.015286462 3.01025390625 0.01529166 3.01025390625 0.015291662 3.0810546875 0.01529688 3.0810546875 0.015296882 3.15185546875 0.01530208 3.15185546875 0.015302082 3.22265625 0.0153073 3.22265625 0.015307302 3.292236328125 0.0153125 3.292236328125 0.015312502 3.360595703125 0.0153177 3.360595703125 0.015317702 3.427734375 0.01532292 3.427734375 0.015322922 3.494873046875 0.01532812 3.494873046875 0.015328122 3.5595703125 0.01533334 3.5595703125 0.015333342 3.624267578125 0.01533854 3.624267578125 0.015338542 3.687744140625 0.01534376 3.687744140625 0.015343762 3.748779296875 0.01534896 3.748779296875 0.015348962 3.809814453125 0.01535416 3.809814453125 0.015354162 3.868408203125 0.01535938 3.868408203125 0.015359382 3.927001953125 0.01536458 3.927001953125 0.015364582 3.98193359375 0.0153698 3.98193359375 0.015369802 4.036865234375 0.015375 4.036865234375 0.015375002 4.090576171875 0.0153802 4.090576171875 0.015380202 4.140625 0.01538542 4.140625 0.015385422 4.190673828125 0.01539062 4.190673828125 0.015390622 4.23828125 0.01539584 4.23828125 0.015395842 4.283447265625 0.01540104 4.283447265625 0.015401042 4.327392578125 0.01540624 4.327392578125 0.015406242 4.3701171875 0.01541146 4.3701171875 0.015411462 4.4091796875 0.01541666 4.4091796875 0.015416662 4.447021484375 0.01542188 4.447021484375 0.015421882 4.483642578125 0.01542708 4.483642578125 0.015427082 4.5166015625 0.0154323 4.5166015625 0.015432302 4.54833984375 0.0154375 4.54833984375 0.015437502 4.57763671875 0.0154427 4.57763671875 0.015442702 4.6044921875 0.01544792 4.6044921875 0.015447922 4.62890625 0.01545312 4.62890625 0.015453122 4.652099609375 0.01545834 4.652099609375 0.015458342 4.671630859375 0.01546354 4.671630859375 0.015463542 4.68994140625 0.01546876 4.68994140625 0.015468762 4.705810546875 0.01547396 4.705810546875 0.015473962 4.71923828125 0.01547916 4.71923828125 0.015479162 4.72900390625 0.01548438 4.72900390625 0.015484382 4.737548828125 0.01548958 4.737548828125 0.015489582 4.74365234375 0.0154948 4.74365234375 0.015494802 4.747314453125 0.0155 4.747314453125 0.015500002 4.74853515625 0.0155052 4.74853515625 0.015505202 4.747314453125 0.01551042 4.747314453125 0.015510422 4.74365234375 0.01551562 4.74365234375 0.015515622 4.737548828125 0.01552084 4.737548828125 0.015520842 4.72900390625 0.01552604 4.72900390625 0.015526042 4.71923828125 0.01553124 4.71923828125 0.015531242 4.705810546875 0.01553646 4.705810546875 0.015536462 4.68994140625 0.01554166 4.68994140625 0.015541662 4.671630859375 0.01554688 4.671630859375 0.015546882 4.652099609375 0.01555208 4.652099609375 0.015552082 4.62890625 0.0155573 4.62890625 0.015557302 4.6044921875 0.0155625 4.6044921875 0.015562502 4.57763671875 0.0155677 4.57763671875 0.015567702 4.54833984375 0.01557292 4.54833984375 0.015572922 4.5166015625 0.01557812 4.5166015625 0.015578122 4.483642578125 0.01558334 4.483642578125 0.015583342 4.447021484375 0.01558854 4.447021484375 0.015588542 4.4091796875 0.01559376 4.4091796875 0.015593762 4.3701171875 0.01559896 4.3701171875 0.015598962 4.327392578125 0.01560416 4.327392578125 0.015604162 4.283447265625 0.01560938 4.283447265625 0.015609382 4.23828125 0.01561458 4.23828125 0.015614582 4.190673828125 0.0156198 4.190673828125 0.015619802 4.140625 0.015625 4.140625 0.015625002 4.090576171875 0.0156302 4.090576171875 0.015630202 4.036865234375 0.01563542 4.036865234375 0.015635422 3.98193359375 0.01564062 3.98193359375 0.015640622 3.927001953125 0.01564584 3.927001953125 0.015645842 3.868408203125 0.01565104 3.868408203125 0.015651042 3.809814453125 0.01565624 3.809814453125 0.015656242 3.748779296875 0.01566146 3.748779296875 0.015661462 3.687744140625 0.01566666 3.687744140625 0.015666662 3.624267578125 0.01567188 3.624267578125 0.015671882 3.5595703125 0.01567708 3.5595703125 0.015677082 3.494873046875 0.0156823 3.494873046875 0.015682302 3.427734375 0.0156875 3.427734375 0.015687502 3.360595703125 0.0156927 3.360595703125 0.015692702 3.292236328125 0.01569792 3.292236328125 0.015697922 3.22265625 0.01570312 3.22265625 0.015703122 3.15185546875 0.01570834 3.15185546875 0.015708342 3.0810546875 0.01571354 3.0810546875 0.015713542 3.01025390625 0.01571876 3.01025390625 0.015718762 2.938232421875 0.01572396 2.938232421875 0.015723962 2.8662109375 0.01572916 2.8662109375 0.015729162 2.79296875 0.01573438 2.79296875 0.015734382 2.7197265625 0.01573958 2.7197265625 0.015739582 2.646484375 0.0157448 2.646484375 0.015744802 2.5732421875 0.01575 2.5732421875 0.015750002 2.5 0.0157552 2.5 0.015755202 2.425537109375 0.01576042 2.425537109375 0.015760422 2.352294921875 0.01576562 2.352294921875 0.015765622 2.279052734375 0.01577084 2.279052734375 0.015770842 2.205810546875 0.01577604 2.205810546875 0.015776042 2.132568359375 0.01578124 2.132568359375 0.015781242 2.060546875 0.01578646 2.060546875 0.015786462 1.988525390625 0.01579166 1.988525390625 0.015791662 1.917724609375 0.01579688 1.917724609375 0.015796882 1.846923828125 0.01580208 1.846923828125 0.015802082 1.776123046875 0.0158073 1.776123046875 0.015807302 1.70654296875 0.0158125 1.70654296875 0.015812502 1.63818359375 0.0158177 1.63818359375 0.015817702 1.571044921875 0.01582292 1.571044921875 0.015822922 1.50390625 0.01582812 1.50390625 0.015828122 1.439208984375 0.01583334 1.439208984375 0.015833342 1.37451171875 0.01583854 1.37451171875 0.015838542 1.31103515625 0.01584376 1.31103515625 0.015843762 1.25 0.01584896 1.25 0.015848962 1.18896484375 0.01585416 1.18896484375 0.015854162 1.13037109375 0.01585938 1.13037109375 0.015859382 1.07177734375 0.01586458 1.07177734375 0.015864582 1.016845703125 0.0158698 1.016845703125 0.015869802 0.9619140625 0.015875 0.9619140625 0.015875002 0.908203125 0.0158802 0.908203125 0.015880202 0.858154296875 0.01588542 0.858154296875 0.015885422 0.80810546875 0.01589062 0.80810546875 0.015890622 0.760498046875 0.01589584 0.760498046875 0.015895842 0.71533203125 0.01590104 0.71533203125 0.015901042 0.67138671875 0.01590624 0.67138671875 0.015906242 0.628662109375 0.01591146 0.628662109375 0.015911462 0.589599609375 0.01591666 0.589599609375 0.015916662 0.5517578125 0.01592188 0.5517578125 0.015921882 0.51513671875 0.01592708 0.51513671875 0.015927082 0.482177734375 0.0159323 0.482177734375 0.015932302 0.450439453125 0.0159375 0.450439453125 0.015937502 0.421142578125 0.0159427 0.421142578125 0.015942702 0.394287109375 0.01594792 0.394287109375 0.015947922 0.369873046875 0.01595312 0.369873046875 0.015953122 0.3466796875 0.01595834 0.3466796875 0.015958342 0.3271484375 0.01596354 0.3271484375 0.015963542 0.308837890625 0.01596876 0.308837890625 0.015968762 0.29296875 0.01597396 0.29296875 0.015973962 0.279541015625 0.01597916 0.279541015625 0.015979162 0.269775390625 0.01598438 0.269775390625 0.015984382 0.26123046875 0.01598958 0.26123046875 0.015989582 0.255126953125 0.0159948 0.255126953125 0.015994802 0.25146484375 0.016 0.25146484375)
Rb srcb b 5274.69962770183
Rp a p 160.0
Lp p b 150.0
Ls s 0 0.126023944549464
K1 Lp Ls 0.999973332977768
Rs s out .2
Rload out 0 8
Rcore p b 100k
Cpri p b 100p
.save v(a) v(b) v(out) i(Lp) i(Ls)
.tran 100n 0.016 0 100n
.end
