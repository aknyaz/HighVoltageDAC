Parallel resistive DAC - 5 V verification only
Vref ref 0 5
.model ideal SW(Ron=1u Roff=1e12 Vt=.5 Vh=0)
.options reltol=1e-7 abstol=1e-13
Va0 ca0 0 PWL(0 0 2.08333333333e-05 0 2.08343333333e-05 1 4.16666666667e-05 1 4.16676666667e-05 0 6.77083333333e-05 0 6.77093333333e-05 1 8.85416666667e-05 1 8.85426666667e-05 0 0.000114583333333 0 0.000114584333333 1 0.000145833333333 1 0.000145834333333 0 0.000192708333333 0 0.000192709333333 1 0.000307291666667 1 0.000307292666667 0 0.000354166666667 0 0.000354167666667 1 0.000385416666667 1 0.000385417666667 0 0.000411458333333 0 0.000411459333333 1 0.000432291666667 1 0.000432292666667 0 0.000458333333333 0 0.000458334333333 1 0.000479166666667 1 0.000479167666667 0 0.0005 0 0.000500001 1 0.000520833333333 1 0.000520834333333 0 0.000541666666667 0 0.000541667666667 1 0.000567708333333 1 0.000567709333333 0 0.000588541666667 0 0.000588542666667 1 0.000614583333333 1 0.000614584333333 0 0.000645833333333 0 0.000645834333333 1 0.000692708333333 1 0.000692709333333 0 0.000807291666667 0 0.000807292666667 1 0.000854166666667 1 0.000854167666667 0 0.000885416666667 0 0.000885417666667 1 0.000911458333333 1 0.000911459333333 0 0.000932291666667 0 0.000932292666667 1 0.000958333333333 1 0.000958334333333 0 0.000979166666667 0 0.000979167666667 1)
Ba0 na0 0 V=1-v(ca0)
Sa0h da0 ref ca0 0 ideal
Sa0l da0 0 na0 0 ideal
Ra0 a da0 29744.8782245
Va1 ca1 0 PWL(0 0 4.16666666667e-05 0 4.16676666667e-05 1 8.85416666667e-05 1 8.85426666667e-05 0 0.000145833333333 0 0.000145834333333 1 0.000354166666667 1 0.000354167666667 0 0.000411458333333 0 0.000411459333333 1 0.000458333333333 1 0.000458334333333 0 0.0005 0 0.000500001 1 0.000541666666667 1 0.000541667666667 0 0.000588541666667 0 0.000588542666667 1 0.000645833333333 1 0.000645834333333 0 0.000854166666667 0 0.000854167666667 1 0.000911458333333 1 0.000911459333333 0 0.000958333333333 0 0.000958334333333 1)
Ba1 na1 0 V=1-v(ca1)
Sa1h da1 ref ca1 0 ideal
Sa1l da1 0 na1 0 ideal
Ra1 a da1 14872.4391122
Va2 ca2 0 PWL(0 1 0.000588541666667 1 0.000588542666667 0 0.000911458333333 0 0.000911459333333 1)
Ba2 na2 0 V=1-v(ca2)
Sa2h da2 ref ca2 0 ideal
Sa2l da2 0 na2 0 ideal
Ra2 a da2 7436.21955612
Va3 ca3 0 PWL(0 1 0.0005 1 0.000500001 0)
Ba3 na3 0 V=1-v(ca3)
Sa3h da3 ref ca3 0 ideal
Sa3l da3 0 na3 0 ideal
Ra3 a da3 7436.21955612
Va4 ca4 0 PWL(0 0 8.85416666667e-05 0 8.85426666667e-05 1 0.000411458333333 1 0.000411459333333 0)
Ba4 na4 0 V=1-v(ca4)
Sa4h da4 ref ca4 0 ideal
Sa4l da4 0 na4 0 ideal
Ra4 a da4 7436.21955612
Raterm a 0 29744.8782245
Vb0 cb0 0 PWL(0 1 2.08333333333e-05 1 2.08343333333e-05 0 4.16666666667e-05 0 4.16676666667e-05 1 6.77083333333e-05 1 6.77093333333e-05 0 8.85416666667e-05 0 8.85426666667e-05 1 0.000114583333333 1 0.000114584333333 0 0.000145833333333 0 0.000145834333333 1 0.000192708333333 1 0.000192709333333 0 0.000307291666667 0 0.000307292666667 1 0.000354166666667 1 0.000354167666667 0 0.000385416666667 0 0.000385417666667 1 0.000411458333333 1 0.000411459333333 0 0.000432291666667 0 0.000432292666667 1 0.000458333333333 1 0.000458334333333 0 0.000479166666667 0 0.000479167666667 1 0.0005 1 0.000500001 0 0.000520833333333 0 0.000520834333333 1 0.000541666666667 1 0.000541667666667 0 0.000567708333333 0 0.000567709333333 1 0.000588541666667 1 0.000588542666667 0 0.000614583333333 0 0.000614584333333 1 0.000645833333333 1 0.000645834333333 0 0.000692708333333 0 0.000692709333333 1 0.000807291666667 1 0.000807292666667 0 0.000854166666667 0 0.000854167666667 1 0.000885416666667 1 0.000885417666667 0 0.000911458333333 0 0.000911459333333 1 0.000932291666667 1 0.000932292666667 0 0.000958333333333 0 0.000958334333333 1 0.000979166666667 1 0.000979167666667 0)
Bb0 nb0 0 V=1-v(cb0)
Sb0h db0 ref cb0 0 ideal
Sb0l db0 0 nb0 0 ideal
Rb0 b db0 29744.8782245
Vb1 cb1 0 PWL(0 1 4.16666666667e-05 1 4.16676666667e-05 0 8.85416666667e-05 0 8.85426666667e-05 1 0.000145833333333 1 0.000145834333333 0 0.000354166666667 0 0.000354167666667 1 0.000411458333333 1 0.000411459333333 0 0.000458333333333 0 0.000458334333333 1 0.0005 1 0.000500001 0 0.000541666666667 0 0.000541667666667 1 0.000588541666667 1 0.000588542666667 0 0.000645833333333 0 0.000645834333333 1 0.000854166666667 1 0.000854167666667 0 0.000911458333333 0 0.000911459333333 1 0.000958333333333 1 0.000958334333333 0)
Bb1 nb1 0 V=1-v(cb1)
Sb1h db1 ref cb1 0 ideal
Sb1l db1 0 nb1 0 ideal
Rb1 b db1 14872.4391122
Vb2 cb2 0 PWL(0 1 8.85416666667e-05 1 8.85426666667e-05 0 0.000411458333333 0 0.000411459333333 1)
Bb2 nb2 0 V=1-v(cb2)
Sb2h db2 ref cb2 0 ideal
Sb2l db2 0 nb2 0 ideal
Rb2 b db2 7436.21955612
Vb3 cb3 0 PWL(0 0 0.0005 0 0.000500001 1)
Bb3 nb3 0 V=1-v(cb3)
Sb3h db3 ref cb3 0 ideal
Sb3l db3 0 nb3 0 ideal
Rb3 b db3 7436.21955612
Vb4 cb4 0 PWL(0 0 0.000588541666667 0 0.000588542666667 1 0.000911458333333 1 0.000911459333333 0)
Bb4 nb4 0 V=1-v(cb4)
Sb4h db4 ref cb4 0 ideal
Sb4l db4 0 nb4 0 ideal
Rb4 b db4 7436.21955612
Rbterm b 0 29744.8782245
Rload a b 10000
.tran 100n 0.001 0 100n
.end
