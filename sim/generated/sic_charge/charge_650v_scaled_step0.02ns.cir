Nonlinear Coss pair - scaled 5 V energy verification
Vref ref 0 5
Vdrive x 0 PWL(0 0 1u 0 1.1u 5)
Bcl x 0 I=ddt((3.5e-10*min(130*v(x),0)+2e-11*max(130*v(x)-1200,0)+(3.5e-10*(min(max((130*v(x)-0),0),5))+-1.7e-11*(min(max((130*v(x)-0),0),5))^2)+(1.8e-10*(min(max((130*v(x)-5),0),5))+-4e-12*(min(max((130*v(x)-5),0),5))^2)+(1.4e-10*(min(max((130*v(x)-10),0),5))+-3e-12*(min(max((130*v(x)-10),0),5))^2)+(1.1e-10*(min(max((130*v(x)-15),0),5))+-1.5e-12*(min(max((130*v(x)-15),0),5))^2)+(9.5e-11*(min(max((130*v(x)-20),0),10))+-9e-13*(min(max((130*v(x)-20),0),10))^2)+(7.7e-11*(min(max((130*v(x)-30),0),10))+-6.5e-13*(min(max((130*v(x)-30),0),10))^2)+(6.4e-11*(min(max((130*v(x)-40),0),10))+-3.5e-13*(min(max((130*v(x)-40),0),10))^2)+(5.7e-11*(min(max((130*v(x)-50),0),25))+-2e-13*(min(max((130*v(x)-50),0),25))^2)+(4.7e-11*(min(max((130*v(x)-75),0),25))+-1.2e-13*(min(max((130*v(x)-75),0),25))^2)+(4.1e-11*(min(max((130*v(x)-100),0),50))+-8e-14*(min(max((130*v(x)-100),0),50))^2)+(3.3e-11*(min(max((130*v(x)-150),0),50))+-3e-14*(min(max((130*v(x)-150),0),50))^2)+(3e-11*(min(max((130*v(x)-200),0),100))+-2.5e-14*(min(max((130*v(x)-200),0),100))^2)+(2.5e-11*(min(max((130*v(x)-300),0),100))+-1.5e-14*(min(max((130*v(x)-300),0),100))^2)+(2.2e-11*(min(max((130*v(x)-400),0),200))+-5e-15*(min(max((130*v(x)-400),0),200))^2)+(2e-11*(min(max((130*v(x)-600),0),200))+0*(min(max((130*v(x)-600),0),200))^2)+(2e-11*(min(max((130*v(x)-800),0),200))+0*(min(max((130*v(x)-800),0),200))^2)+(2e-11*(min(max((130*v(x)-1000),0),200))+0*(min(max((130*v(x)-1000),0),200))^2))/130)
Bch ref x I=ddt((3.5e-10*min(130*v(ref,x),0)+2e-11*max(130*v(ref,x)-1200,0)+(3.5e-10*(min(max((130*v(ref,x)-0),0),5))+-1.7e-11*(min(max((130*v(ref,x)-0),0),5))^2)+(1.8e-10*(min(max((130*v(ref,x)-5),0),5))+-4e-12*(min(max((130*v(ref,x)-5),0),5))^2)+(1.4e-10*(min(max((130*v(ref,x)-10),0),5))+-3e-12*(min(max((130*v(ref,x)-10),0),5))^2)+(1.1e-10*(min(max((130*v(ref,x)-15),0),5))+-1.5e-12*(min(max((130*v(ref,x)-15),0),5))^2)+(9.5e-11*(min(max((130*v(ref,x)-20),0),10))+-9e-13*(min(max((130*v(ref,x)-20),0),10))^2)+(7.7e-11*(min(max((130*v(ref,x)-30),0),10))+-6.5e-13*(min(max((130*v(ref,x)-30),0),10))^2)+(6.4e-11*(min(max((130*v(ref,x)-40),0),10))+-3.5e-13*(min(max((130*v(ref,x)-40),0),10))^2)+(5.7e-11*(min(max((130*v(ref,x)-50),0),25))+-2e-13*(min(max((130*v(ref,x)-50),0),25))^2)+(4.7e-11*(min(max((130*v(ref,x)-75),0),25))+-1.2e-13*(min(max((130*v(ref,x)-75),0),25))^2)+(4.1e-11*(min(max((130*v(ref,x)-100),0),50))+-8e-14*(min(max((130*v(ref,x)-100),0),50))^2)+(3.3e-11*(min(max((130*v(ref,x)-150),0),50))+-3e-14*(min(max((130*v(ref,x)-150),0),50))^2)+(3e-11*(min(max((130*v(ref,x)-200),0),100))+-2.5e-14*(min(max((130*v(ref,x)-200),0),100))^2)+(2.5e-11*(min(max((130*v(ref,x)-300),0),100))+-1.5e-14*(min(max((130*v(ref,x)-300),0),100))^2)+(2.2e-11*(min(max((130*v(ref,x)-400),0),200))+-5e-15*(min(max((130*v(ref,x)-400),0),200))^2)+(2e-11*(min(max((130*v(ref,x)-600),0),200))+0*(min(max((130*v(ref,x)-600),0),200))^2)+(2e-11*(min(max((130*v(ref,x)-800),0),200))+0*(min(max((130*v(ref,x)-800),0),200))^2)+(2e-11*(min(max((130*v(ref,x)-1000),0),200))+0*(min(max((130*v(ref,x)-1000),0),200))^2))/130)
.options reltol=1e-7 abstol=1e-14 method=gear
.tran 0.02n 1.2u 0 0.02n
.end
