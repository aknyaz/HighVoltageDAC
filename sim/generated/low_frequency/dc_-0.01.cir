20 Hz continuous Thevenin model / 5 V / linear LL1679
Vsrc src 0 DC -0.04998779296875
Rsrc src p 10709.3992554037
Lp p 0 150.0
Ls s 0 0.126023944549464
K1 Lp Ls 0.999973332977768
Rsec s out .2
Rload out 0 8
Rcore p 0 100000.0
Cpri p 0 1e-10
.options reltol=1e-8 abstol=1e-14 method=gear
.save v(src) v(p) v(out) i(Lp) i(Ls)
.op
.end
