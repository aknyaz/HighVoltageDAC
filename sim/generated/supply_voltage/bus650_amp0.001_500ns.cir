Audio viability / LL1679 / 650 V / 200 ns blanking / 20 pF
Vref ref 0 650
.options reltol=1e-6 abstol=1e-12 method=gear
Va0_1 ca0_1 0 PWL(0 1 2.6e-06 1 2.602e-06 0 8.614e-05 0 8.6142e-05 1 0.00021614 1 0.000216142 0 0.00028926 0 0.000289262 1 0.00041928 1 0.000419282 0 0.0005028 0 0.000502802 1 0.00058594 1 0.000585942 0 0.00071634 0 0.000716342 1 0.00078906 1 0.000789062 0 0.00091948 0 0.000919482 1 .001 1) r=0
Ba0_1 da0 ref I=v(da0,ref)*(1e-12+(1/.35-1e-12)*v(ca0_1))
Ca0_1 da0 ref 20p
Va0_0 ca0_0 0 PWL(0 0 2.8e-06 0 2.802e-06 1 8.594e-05 1 8.5942e-05 0 0.00021634 0 0.000216342 1 0.00028906 1 0.000289062 0 0.00041948 0 0.000419482 1 0.0005026 1 0.000502602 0 0.00058614 0 0.000586142 1 0.00071614 1 0.000716142 0 0.00078926 0 0.000789262 1 0.00091928 1 0.000919282 0 .001 0) r=0
Ba0_0 da0 0 I=v(da0,0)*(1e-12+(1/.35-1e-12)*v(ca0_0))
Ca0_0 da0 0 20p
Ra0 a da0 21605169.6750667
Bdla0 0 da0 I=max(-v(da0)-0.7,0)/2
Bdha0 da0 ref I=max(v(da0)-650.7,0)/2
Va1_1 ca1_1 0 PWL(0 1 2.6e-06 1 2.602e-06 0 0.00021634 0 0.000216342 1 0.00028906 1 0.000289062 0 0.0005028 0 0.000502802 1 0.00071614 1 0.000716142 0 0.00078926 0 0.000789262 1 .001 1) r=0
Ba1_1 da1 ref I=v(da1,ref)*(1e-12+(1/.35-1e-12)*v(ca1_1))
Ca1_1 da1 ref 20p
Va1_0 ca1_0 0 PWL(0 0 2.8e-06 0 2.802e-06 1 0.00021614 1 0.000216142 0 0.00028926 0 0.000289262 1 0.0005026 1 0.000502602 0 0.00071634 0 0.000716342 1 0.00078906 1 0.000789062 0 .001 0) r=0
Ba1_0 da1 0 I=v(da1,0)*(1e-12+(1/.35-1e-12)*v(ca1_0))
Ca1_0 da1 0 20p
Ra1 a da1 10802584.8375334
Bdla1 0 da1 I=max(-v(da1)-0.7,0)/2
Bdha1 da1 ref I=max(v(da1)-650.7,0)/2
Va2_1 ca2_1 0 PWL(0 1 2.6e-06 1 2.602e-06 0 0.0005028 0 0.000502802 1 .001 1) r=0
Ba2_1 da2 ref I=v(da2,ref)*(1e-12+(1/.35-1e-12)*v(ca2_1))
Ca2_1 da2 ref 20p
Va2_0 ca2_0 0 PWL(0 0 2.8e-06 0 2.802e-06 1 0.0005026 1 0.000502602 0 .001 0) r=0
Ba2_0 da2 0 I=v(da2,0)*(1e-12+(1/.35-1e-12)*v(ca2_0))
Ca2_0 da2 0 20p
Ra2 a da2 5401292.41876668
Bdla2 0 da2 I=max(-v(da2)-0.7,0)/2
Bdha2 da2 ref I=max(v(da2)-650.7,0)/2
Va3_1 ca3_1 0 PWL(0 1 2.6e-06 1 2.602e-06 0 0.0005028 0 0.000502802 1 .001 1) r=0
Ba3_1 da3 ref I=v(da3,ref)*(1e-12+(1/.35-1e-12)*v(ca3_1))
Ca3_1 da3 ref 20p
Va3_0 ca3_0 0 PWL(0 0 2.8e-06 0 2.802e-06 1 0.0005026 1 0.000502602 0 .001 0) r=0
Ba3_0 da3 0 I=v(da3,0)*(1e-12+(1/.35-1e-12)*v(ca3_0))
Ca3_0 da3 0 20p
Ra3 a da3 2700646.20938334
Bdla3 0 da3 I=max(-v(da3)-0.7,0)/2
Bdha3 da3 ref I=max(v(da3)-650.7,0)/2
Va4_1 ca4_1 0 PWL(0 1 2.6e-06 1 2.602e-06 0 0.0005028 0 0.000502802 1 .001 1) r=0
Ba4_1 da4 ref I=v(da4,ref)*(1e-12+(1/.35-1e-12)*v(ca4_1))
Ca4_1 da4 ref 20p
Va4_0 ca4_0 0 PWL(0 0 2.8e-06 0 2.802e-06 1 0.0005026 1 0.000502602 0 .001 0) r=0
Ba4_0 da4 0 I=v(da4,0)*(1e-12+(1/.35-1e-12)*v(ca4_0))
Ca4_0 da4 0 20p
Ra4 a da4 1350323.10469167
Bdla4 0 da4 I=max(-v(da4)-0.7,0)/2
Bdha4 da4 ref I=max(v(da4)-650.7,0)/2
Va5_1 ca5_1 0 PWL(0 1 2.6e-06 1 2.602e-06 0 0.0005028 0 0.000502802 1 .001 1) r=0
Ba5_1 da5 ref I=v(da5,ref)*(1e-12+(1/.35-1e-12)*v(ca5_1))
Ca5_1 da5 ref 20p
Va5_0 ca5_0 0 PWL(0 0 2.8e-06 0 2.802e-06 1 0.0005026 1 0.000502602 0 .001 0) r=0
Ba5_0 da5 0 I=v(da5,0)*(1e-12+(1/.35-1e-12)*v(ca5_0))
Ca5_0 da5 0 20p
Ra5 a da5 675161.552345835
Bdla5 0 da5 I=max(-v(da5)-0.7,0)/2
Bdha5 da5 ref I=max(v(da5)-650.7,0)/2
Va6_1 ca6_1 0 PWL(0 1 2.6e-06 1 2.602e-06 0 0.0005028 0 0.000502802 1 .001 1) r=0
Ba6_1 da6 ref I=v(da6,ref)*(1e-12+(1/.35-1e-12)*v(ca6_1))
Ca6_1 da6 ref 20p
Va6_0 ca6_0 0 PWL(0 0 2.8e-06 0 2.802e-06 1 0.0005026 1 0.000502602 0 .001 0) r=0
Ba6_0 da6 0 I=v(da6,0)*(1e-12+(1/.35-1e-12)*v(ca6_0))
Ca6_0 da6 0 20p
Ra6 a da6 337580.776172917
Bdla6 0 da6 I=max(-v(da6)-0.7,0)/2
Bdha6 da6 ref I=max(v(da6)-650.7,0)/2
Va7_1 ca7_1 0 PWL(0 1 2.6e-06 1 2.602e-06 0 0.0005028 0 0.000502802 1 .001 1) r=0
Ba7_1 da7 ref I=v(da7,ref)*(1e-12+(1/.35-1e-12)*v(ca7_1))
Ca7_1 da7 ref 20p
Va7_0 ca7_0 0 PWL(0 0 2.8e-06 0 2.802e-06 1 0.0005026 1 0.000502602 0 .001 0) r=0
Ba7_0 da7 0 I=v(da7,0)*(1e-12+(1/.35-1e-12)*v(ca7_0))
Ca7_0 da7 0 20p
Ra7 a da7 168790.388086459
Bdla7 0 da7 I=max(-v(da7)-0.7,0)/2
Bdha7 da7 ref I=max(v(da7)-650.7,0)/2
Va8_1 ca8_1 0 PWL(0 1 2.6e-06 1 2.602e-06 0 0.0005028 0 0.000502802 1 .001 1) r=0
Ba8_1 da8 ref I=v(da8,ref)*(1e-12+(1/.35-1e-12)*v(ca8_1))
Ca8_1 da8 ref 20p
Va8_0 ca8_0 0 PWL(0 0 2.8e-06 0 2.802e-06 1 0.0005026 1 0.000502602 0 .001 0) r=0
Ba8_0 da8 0 I=v(da8,0)*(1e-12+(1/.35-1e-12)*v(ca8_0))
Ca8_0 da8 0 20p
Ra8 a da8 84395.1940432293
Bdla8 0 da8 I=max(-v(da8)-0.7,0)/2
Bdha8 da8 ref I=max(v(da8)-650.7,0)/2
Va9_1 ca9_1 0 PWL(0 1 .001 1) r=0
Ba9_1 da9 ref I=v(da9,ref)*(1e-12+(1/.35-1e-12)*v(ca9_1))
Ca9_1 da9 ref 20p
Va9_0 ca9_0 0 PWL(0 0 .001 0) r=0
Ba9_0 da9 0 I=v(da9,0)*(1e-12+(1/.35-1e-12)*v(ca9_0))
Ca9_0 da9 0 20p
Ra9 a da9 42197.5970216147
Bdla9 0 da9 I=max(-v(da9)-0.7,0)/2
Bdha9 da9 ref I=max(v(da9)-650.7,0)/2
Va10_1 ca10_1 0 PWL(0 1 .001 1) r=0
Ba10_1 da10 ref I=v(da10,ref)*(1e-12+(1/.35-1e-12)*v(ca10_1))
Ca10_1 da10 ref 20p
Va10_0 ca10_0 0 PWL(0 0 .001 0) r=0
Ba10_0 da10 0 I=v(da10,0)*(1e-12+(1/.35-1e-12)*v(ca10_0))
Ca10_0 da10 0 20p
Ra10 a da10 42197.5970216147
Bdla10 0 da10 I=max(-v(da10)-0.7,0)/2
Bdha10 da10 ref I=max(v(da10)-650.7,0)/2
Va11_1 ca11_1 0 PWL(0 1 .001 1) r=0
Ba11_1 da11 ref I=v(da11,ref)*(1e-12+(1/.35-1e-12)*v(ca11_1))
Ca11_1 da11 ref 20p
Va11_0 ca11_0 0 PWL(0 0 .001 0) r=0
Ba11_0 da11 0 I=v(da11,0)*(1e-12+(1/.35-1e-12)*v(ca11_0))
Ca11_0 da11 0 20p
Ra11 a da11 42197.5970216147
Bdla11 0 da11 I=max(-v(da11)-0.7,0)/2
Bdha11 da11 ref I=max(v(da11)-650.7,0)/2
Va12_1 ca12_1 0 PWL(0 0 2.8e-06 0 2.802e-06 1 0.0005026 1 0.000502602 0 .001 0) r=0
Ba12_1 da12 ref I=v(da12,ref)*(1e-12+(1/.35-1e-12)*v(ca12_1))
Ca12_1 da12 ref 20p
Va12_0 ca12_0 0 PWL(0 1 2.6e-06 1 2.602e-06 0 0.0005028 0 0.000502802 1 .001 1) r=0
Ba12_0 da12 0 I=v(da12,0)*(1e-12+(1/.35-1e-12)*v(ca12_0))
Ca12_0 da12 0 20p
Ra12 a da12 42197.5970216147
Bdla12 0 da12 I=max(-v(da12)-0.7,0)/2
Bdha12 da12 ref I=max(v(da12)-650.7,0)/2
Va13_1 ca13_1 0 PWL(0 0 .001 0) r=0
Ba13_1 da13 ref I=v(da13,ref)*(1e-12+(1/.35-1e-12)*v(ca13_1))
Ca13_1 da13 ref 20p
Va13_0 ca13_0 0 PWL(0 1 .001 1) r=0
Ba13_0 da13 0 I=v(da13,0)*(1e-12+(1/.35-1e-12)*v(ca13_0))
Ca13_0 da13 0 20p
Ra13 a da13 42197.5970216147
Bdla13 0 da13 I=max(-v(da13)-0.7,0)/2
Bdha13 da13 ref I=max(v(da13)-650.7,0)/2
Va14_1 ca14_1 0 PWL(0 0 .001 0) r=0
Ba14_1 da14 ref I=v(da14,ref)*(1e-12+(1/.35-1e-12)*v(ca14_1))
Ca14_1 da14 ref 20p
Va14_0 ca14_0 0 PWL(0 1 .001 1) r=0
Ba14_0 da14 0 I=v(da14,0)*(1e-12+(1/.35-1e-12)*v(ca14_0))
Ca14_0 da14 0 20p
Ra14 a da14 42197.5970216147
Bdla14 0 da14 I=max(-v(da14)-0.7,0)/2
Bdha14 da14 ref I=max(v(da14)-650.7,0)/2
Va15_1 ca15_1 0 PWL(0 0 .001 0) r=0
Ba15_1 da15 ref I=v(da15,ref)*(1e-12+(1/.35-1e-12)*v(ca15_1))
Ca15_1 da15 ref 20p
Va15_0 ca15_0 0 PWL(0 1 .001 1) r=0
Ba15_0 da15 0 I=v(da15,0)*(1e-12+(1/.35-1e-12)*v(ca15_0))
Ca15_0 da15 0 20p
Ra15 a da15 42197.5970216147
Bdla15 0 da15 I=max(-v(da15)-0.7,0)/2
Bdha15 da15 ref I=max(v(da15)-650.7,0)/2
Rta a 0 21605169.6750667
Vb0_1 cb0_1 0 PWL(0 0 2.8e-06 0 2.802e-06 1 8.594e-05 1 8.5942e-05 0 0.00021634 0 0.000216342 1 0.00028906 1 0.000289062 0 0.00041948 0 0.000419482 1 0.0005026 1 0.000502602 0 0.00058614 0 0.000586142 1 0.00071614 1 0.000716142 0 0.00078926 0 0.000789262 1 0.00091928 1 0.000919282 0 .001 0) r=0
Bb0_1 db0 ref I=v(db0,ref)*(1e-12+(1/.35-1e-12)*v(cb0_1))
Cb0_1 db0 ref 20p
Vb0_0 cb0_0 0 PWL(0 1 2.6e-06 1 2.602e-06 0 8.614e-05 0 8.6142e-05 1 0.00021614 1 0.000216142 0 0.00028926 0 0.000289262 1 0.00041928 1 0.000419282 0 0.0005028 0 0.000502802 1 0.00058594 1 0.000585942 0 0.00071634 0 0.000716342 1 0.00078906 1 0.000789062 0 0.00091948 0 0.000919482 1 .001 1) r=0
Bb0_0 db0 0 I=v(db0,0)*(1e-12+(1/.35-1e-12)*v(cb0_0))
Cb0_0 db0 0 20p
Rb0 b db0 21605169.6750667
Bdlb0 0 db0 I=max(-v(db0)-0.7,0)/2
Bdhb0 db0 ref I=max(v(db0)-650.7,0)/2
Vb1_1 cb1_1 0 PWL(0 0 2.8e-06 0 2.802e-06 1 0.00021614 1 0.000216142 0 0.00028926 0 0.000289262 1 0.0005026 1 0.000502602 0 0.00071634 0 0.000716342 1 0.00078906 1 0.000789062 0 .001 0) r=0
Bb1_1 db1 ref I=v(db1,ref)*(1e-12+(1/.35-1e-12)*v(cb1_1))
Cb1_1 db1 ref 20p
Vb1_0 cb1_0 0 PWL(0 1 2.6e-06 1 2.602e-06 0 0.00021634 0 0.000216342 1 0.00028906 1 0.000289062 0 0.0005028 0 0.000502802 1 0.00071614 1 0.000716142 0 0.00078926 0 0.000789262 1 .001 1) r=0
Bb1_0 db1 0 I=v(db1,0)*(1e-12+(1/.35-1e-12)*v(cb1_0))
Cb1_0 db1 0 20p
Rb1 b db1 10802584.8375334
Bdlb1 0 db1 I=max(-v(db1)-0.7,0)/2
Bdhb1 db1 ref I=max(v(db1)-650.7,0)/2
Vb2_1 cb2_1 0 PWL(0 0 2.8e-06 0 2.802e-06 1 0.0005026 1 0.000502602 0 .001 0) r=0
Bb2_1 db2 ref I=v(db2,ref)*(1e-12+(1/.35-1e-12)*v(cb2_1))
Cb2_1 db2 ref 20p
Vb2_0 cb2_0 0 PWL(0 1 2.6e-06 1 2.602e-06 0 0.0005028 0 0.000502802 1 .001 1) r=0
Bb2_0 db2 0 I=v(db2,0)*(1e-12+(1/.35-1e-12)*v(cb2_0))
Cb2_0 db2 0 20p
Rb2 b db2 5401292.41876668
Bdlb2 0 db2 I=max(-v(db2)-0.7,0)/2
Bdhb2 db2 ref I=max(v(db2)-650.7,0)/2
Vb3_1 cb3_1 0 PWL(0 0 2.8e-06 0 2.802e-06 1 0.0005026 1 0.000502602 0 .001 0) r=0
Bb3_1 db3 ref I=v(db3,ref)*(1e-12+(1/.35-1e-12)*v(cb3_1))
Cb3_1 db3 ref 20p
Vb3_0 cb3_0 0 PWL(0 1 2.6e-06 1 2.602e-06 0 0.0005028 0 0.000502802 1 .001 1) r=0
Bb3_0 db3 0 I=v(db3,0)*(1e-12+(1/.35-1e-12)*v(cb3_0))
Cb3_0 db3 0 20p
Rb3 b db3 2700646.20938334
Bdlb3 0 db3 I=max(-v(db3)-0.7,0)/2
Bdhb3 db3 ref I=max(v(db3)-650.7,0)/2
Vb4_1 cb4_1 0 PWL(0 0 2.8e-06 0 2.802e-06 1 0.0005026 1 0.000502602 0 .001 0) r=0
Bb4_1 db4 ref I=v(db4,ref)*(1e-12+(1/.35-1e-12)*v(cb4_1))
Cb4_1 db4 ref 20p
Vb4_0 cb4_0 0 PWL(0 1 2.6e-06 1 2.602e-06 0 0.0005028 0 0.000502802 1 .001 1) r=0
Bb4_0 db4 0 I=v(db4,0)*(1e-12+(1/.35-1e-12)*v(cb4_0))
Cb4_0 db4 0 20p
Rb4 b db4 1350323.10469167
Bdlb4 0 db4 I=max(-v(db4)-0.7,0)/2
Bdhb4 db4 ref I=max(v(db4)-650.7,0)/2
Vb5_1 cb5_1 0 PWL(0 0 2.8e-06 0 2.802e-06 1 0.0005026 1 0.000502602 0 .001 0) r=0
Bb5_1 db5 ref I=v(db5,ref)*(1e-12+(1/.35-1e-12)*v(cb5_1))
Cb5_1 db5 ref 20p
Vb5_0 cb5_0 0 PWL(0 1 2.6e-06 1 2.602e-06 0 0.0005028 0 0.000502802 1 .001 1) r=0
Bb5_0 db5 0 I=v(db5,0)*(1e-12+(1/.35-1e-12)*v(cb5_0))
Cb5_0 db5 0 20p
Rb5 b db5 675161.552345835
Bdlb5 0 db5 I=max(-v(db5)-0.7,0)/2
Bdhb5 db5 ref I=max(v(db5)-650.7,0)/2
Vb6_1 cb6_1 0 PWL(0 0 2.8e-06 0 2.802e-06 1 0.0005026 1 0.000502602 0 .001 0) r=0
Bb6_1 db6 ref I=v(db6,ref)*(1e-12+(1/.35-1e-12)*v(cb6_1))
Cb6_1 db6 ref 20p
Vb6_0 cb6_0 0 PWL(0 1 2.6e-06 1 2.602e-06 0 0.0005028 0 0.000502802 1 .001 1) r=0
Bb6_0 db6 0 I=v(db6,0)*(1e-12+(1/.35-1e-12)*v(cb6_0))
Cb6_0 db6 0 20p
Rb6 b db6 337580.776172917
Bdlb6 0 db6 I=max(-v(db6)-0.7,0)/2
Bdhb6 db6 ref I=max(v(db6)-650.7,0)/2
Vb7_1 cb7_1 0 PWL(0 0 2.8e-06 0 2.802e-06 1 0.0005026 1 0.000502602 0 .001 0) r=0
Bb7_1 db7 ref I=v(db7,ref)*(1e-12+(1/.35-1e-12)*v(cb7_1))
Cb7_1 db7 ref 20p
Vb7_0 cb7_0 0 PWL(0 1 2.6e-06 1 2.602e-06 0 0.0005028 0 0.000502802 1 .001 1) r=0
Bb7_0 db7 0 I=v(db7,0)*(1e-12+(1/.35-1e-12)*v(cb7_0))
Cb7_0 db7 0 20p
Rb7 b db7 168790.388086459
Bdlb7 0 db7 I=max(-v(db7)-0.7,0)/2
Bdhb7 db7 ref I=max(v(db7)-650.7,0)/2
Vb8_1 cb8_1 0 PWL(0 0 2.8e-06 0 2.802e-06 1 0.0005026 1 0.000502602 0 .001 0) r=0
Bb8_1 db8 ref I=v(db8,ref)*(1e-12+(1/.35-1e-12)*v(cb8_1))
Cb8_1 db8 ref 20p
Vb8_0 cb8_0 0 PWL(0 1 2.6e-06 1 2.602e-06 0 0.0005028 0 0.000502802 1 .001 1) r=0
Bb8_0 db8 0 I=v(db8,0)*(1e-12+(1/.35-1e-12)*v(cb8_0))
Cb8_0 db8 0 20p
Rb8 b db8 84395.1940432293
Bdlb8 0 db8 I=max(-v(db8)-0.7,0)/2
Bdhb8 db8 ref I=max(v(db8)-650.7,0)/2
Vb9_1 cb9_1 0 PWL(0 1 .001 1) r=0
Bb9_1 db9 ref I=v(db9,ref)*(1e-12+(1/.35-1e-12)*v(cb9_1))
Cb9_1 db9 ref 20p
Vb9_0 cb9_0 0 PWL(0 0 .001 0) r=0
Bb9_0 db9 0 I=v(db9,0)*(1e-12+(1/.35-1e-12)*v(cb9_0))
Cb9_0 db9 0 20p
Rb9 b db9 42197.5970216147
Bdlb9 0 db9 I=max(-v(db9)-0.7,0)/2
Bdhb9 db9 ref I=max(v(db9)-650.7,0)/2
Vb10_1 cb10_1 0 PWL(0 1 .001 1) r=0
Bb10_1 db10 ref I=v(db10,ref)*(1e-12+(1/.35-1e-12)*v(cb10_1))
Cb10_1 db10 ref 20p
Vb10_0 cb10_0 0 PWL(0 0 .001 0) r=0
Bb10_0 db10 0 I=v(db10,0)*(1e-12+(1/.35-1e-12)*v(cb10_0))
Cb10_0 db10 0 20p
Rb10 b db10 42197.5970216147
Bdlb10 0 db10 I=max(-v(db10)-0.7,0)/2
Bdhb10 db10 ref I=max(v(db10)-650.7,0)/2
Vb11_1 cb11_1 0 PWL(0 1 .001 1) r=0
Bb11_1 db11 ref I=v(db11,ref)*(1e-12+(1/.35-1e-12)*v(cb11_1))
Cb11_1 db11 ref 20p
Vb11_0 cb11_0 0 PWL(0 0 .001 0) r=0
Bb11_0 db11 0 I=v(db11,0)*(1e-12+(1/.35-1e-12)*v(cb11_0))
Cb11_0 db11 0 20p
Rb11 b db11 42197.5970216147
Bdlb11 0 db11 I=max(-v(db11)-0.7,0)/2
Bdhb11 db11 ref I=max(v(db11)-650.7,0)/2
Vb12_1 cb12_1 0 PWL(0 1 2.6e-06 1 2.602e-06 0 0.0005028 0 0.000502802 1 .001 1) r=0
Bb12_1 db12 ref I=v(db12,ref)*(1e-12+(1/.35-1e-12)*v(cb12_1))
Cb12_1 db12 ref 20p
Vb12_0 cb12_0 0 PWL(0 0 2.8e-06 0 2.802e-06 1 0.0005026 1 0.000502602 0 .001 0) r=0
Bb12_0 db12 0 I=v(db12,0)*(1e-12+(1/.35-1e-12)*v(cb12_0))
Cb12_0 db12 0 20p
Rb12 b db12 42197.5970216147
Bdlb12 0 db12 I=max(-v(db12)-0.7,0)/2
Bdhb12 db12 ref I=max(v(db12)-650.7,0)/2
Vb13_1 cb13_1 0 PWL(0 0 .001 0) r=0
Bb13_1 db13 ref I=v(db13,ref)*(1e-12+(1/.35-1e-12)*v(cb13_1))
Cb13_1 db13 ref 20p
Vb13_0 cb13_0 0 PWL(0 1 .001 1) r=0
Bb13_0 db13 0 I=v(db13,0)*(1e-12+(1/.35-1e-12)*v(cb13_0))
Cb13_0 db13 0 20p
Rb13 b db13 42197.5970216147
Bdlb13 0 db13 I=max(-v(db13)-0.7,0)/2
Bdhb13 db13 ref I=max(v(db13)-650.7,0)/2
Vb14_1 cb14_1 0 PWL(0 0 .001 0) r=0
Bb14_1 db14 ref I=v(db14,ref)*(1e-12+(1/.35-1e-12)*v(cb14_1))
Cb14_1 db14 ref 20p
Vb14_0 cb14_0 0 PWL(0 1 .001 1) r=0
Bb14_0 db14 0 I=v(db14,0)*(1e-12+(1/.35-1e-12)*v(cb14_0))
Cb14_0 db14 0 20p
Rb14 b db14 42197.5970216147
Bdlb14 0 db14 I=max(-v(db14)-0.7,0)/2
Bdhb14 db14 ref I=max(v(db14)-650.7,0)/2
Vb15_1 cb15_1 0 PWL(0 0 .001 0) r=0
Bb15_1 db15 ref I=v(db15,ref)*(1e-12+(1/.35-1e-12)*v(cb15_1))
Cb15_1 db15 ref 20p
Vb15_0 cb15_0 0 PWL(0 1 .001 1) r=0
Bb15_0 db15 0 I=v(db15,0)*(1e-12+(1/.35-1e-12)*v(cb15_0))
Cb15_0 db15 0 20p
Rb15 b db15 42197.5970216147
Bdlb15 0 db15 I=max(-v(db15)-0.7,0)/2
Bdhb15 db15 ref I=max(v(db15)-650.7,0)/2
Rtb b 0 21605169.6750667
Rp a p 160.0
Lp p b 150.0
Ls s 0 0.126023944549464
K1 Lp Ls 0.999973332977768
Rs s out .2
Rload out 0 8
Rcore p b 100k
Cpri p b 100p
.save v(out)
.tran 500n 0.03 0 500n
.end
