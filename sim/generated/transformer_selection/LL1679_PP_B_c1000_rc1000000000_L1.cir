LL1679_PP_B / 1 V AC / datasheet-informed linear screening
Vsrc src 0 DC 0 AC 1
Rsrc src a 10549.3992554037
Rp a p 160.0
Lp p 0 150
Ls s 0 0.126023944549464
K1 Lp Ls 0.999973332977768
Rs s out 0.2
Rload out 0 8
Rcore p 0 1000000000
Cpri p 0 1000p
.ac dec 60 10 1Meg
.end
