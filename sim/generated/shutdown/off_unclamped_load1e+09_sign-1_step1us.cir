Stored energy release: off_unclamped, 5 V, initial magnetizing current -5e-05
Vref ref 0 5
.options reltol=1e-7 abstol=1e-13 method=gear
Ra0 a da0 21605169.6750667
Rha0 da0 ref 1e12
Rla0 da0 0 1000000000000.0
Cha0 da0 ref 20p IC=-5
Cla0 da0 0 20p IC=0
Ra1 a da1 10802584.8375334
Rha1 da1 ref 1e12
Rla1 da1 0 1000000000000.0
Cha1 da1 ref 20p IC=-5
Cla1 da1 0 20p IC=0
Ra2 a da2 5401292.41876668
Rha2 da2 ref 1e12
Rla2 da2 0 1000000000000.0
Cha2 da2 ref 20p IC=-5
Cla2 da2 0 20p IC=0
Ra3 a da3 2700646.20938334
Rha3 da3 ref 1e12
Rla3 da3 0 1000000000000.0
Cha3 da3 ref 20p IC=-5
Cla3 da3 0 20p IC=0
Ra4 a da4 1350323.10469167
Rha4 da4 ref 1e12
Rla4 da4 0 1000000000000.0
Cha4 da4 ref 20p IC=-5
Cla4 da4 0 20p IC=0
Ra5 a da5 675161.552345835
Rha5 da5 ref 1e12
Rla5 da5 0 1000000000000.0
Cha5 da5 ref 20p IC=-5
Cla5 da5 0 20p IC=0
Ra6 a da6 337580.776172917
Rha6 da6 ref 1e12
Rla6 da6 0 1000000000000.0
Cha6 da6 ref 20p IC=-5
Cla6 da6 0 20p IC=0
Ra7 a da7 168790.388086459
Rha7 da7 ref 1e12
Rla7 da7 0 1000000000000.0
Cha7 da7 ref 20p IC=-5
Cla7 da7 0 20p IC=0
Ra8 a da8 84395.1940432293
Rha8 da8 ref 1e12
Rla8 da8 0 1000000000000.0
Cha8 da8 ref 20p IC=-5
Cla8 da8 0 20p IC=0
Ra9 a da9 42197.5970216147
Rha9 da9 ref 1e12
Rla9 da9 0 1000000000000.0
Cha9 da9 ref 20p IC=-5
Cla9 da9 0 20p IC=0
Ra10 a da10 42197.5970216147
Rha10 da10 ref 1e12
Rla10 da10 0 1000000000000.0
Cha10 da10 ref 20p IC=-5
Cla10 da10 0 20p IC=0
Ra11 a da11 42197.5970216147
Rha11 da11 ref 1e12
Rla11 da11 0 1000000000000.0
Cha11 da11 ref 20p IC=-5
Cla11 da11 0 20p IC=0
Ra12 a da12 42197.5970216147
Rha12 da12 ref 1e12
Rla12 da12 0 1000000000000.0
Cha12 da12 ref 20p IC=-5
Cla12 da12 0 20p IC=0
Ra13 a da13 42197.5970216147
Rha13 da13 ref 1e12
Rla13 da13 0 1000000000000.0
Cha13 da13 ref 20p IC=-5
Cla13 da13 0 20p IC=0
Ra14 a da14 42197.5970216147
Rha14 da14 ref 1e12
Rla14 da14 0 1000000000000.0
Cha14 da14 ref 20p IC=-5
Cla14 da14 0 20p IC=0
Ra15 a da15 42197.5970216147
Rha15 da15 ref 1e12
Rla15 da15 0 1000000000000.0
Cha15 da15 ref 20p IC=-5
Cla15 da15 0 20p IC=0
Rta a 0 21605169.6750667
Rb0 b db0 21605169.6750667
Rhb0 db0 ref 1e12
Rlb0 db0 0 1000000000000.0
Chb0 db0 ref 20p IC=-5
Clb0 db0 0 20p IC=0
Rb1 b db1 10802584.8375334
Rhb1 db1 ref 1e12
Rlb1 db1 0 1000000000000.0
Chb1 db1 ref 20p IC=-5
Clb1 db1 0 20p IC=0
Rb2 b db2 5401292.41876668
Rhb2 db2 ref 1e12
Rlb2 db2 0 1000000000000.0
Chb2 db2 ref 20p IC=-5
Clb2 db2 0 20p IC=0
Rb3 b db3 2700646.20938334
Rhb3 db3 ref 1e12
Rlb3 db3 0 1000000000000.0
Chb3 db3 ref 20p IC=-5
Clb3 db3 0 20p IC=0
Rb4 b db4 1350323.10469167
Rhb4 db4 ref 1e12
Rlb4 db4 0 1000000000000.0
Chb4 db4 ref 20p IC=-5
Clb4 db4 0 20p IC=0
Rb5 b db5 675161.552345835
Rhb5 db5 ref 1e12
Rlb5 db5 0 1000000000000.0
Chb5 db5 ref 20p IC=-5
Clb5 db5 0 20p IC=0
Rb6 b db6 337580.776172917
Rhb6 db6 ref 1e12
Rlb6 db6 0 1000000000000.0
Chb6 db6 ref 20p IC=-5
Clb6 db6 0 20p IC=0
Rb7 b db7 168790.388086459
Rhb7 db7 ref 1e12
Rlb7 db7 0 1000000000000.0
Chb7 db7 ref 20p IC=-5
Clb7 db7 0 20p IC=0
Rb8 b db8 84395.1940432293
Rhb8 db8 ref 1e12
Rlb8 db8 0 1000000000000.0
Chb8 db8 ref 20p IC=-5
Clb8 db8 0 20p IC=0
Rb9 b db9 42197.5970216147
Rhb9 db9 ref 1e12
Rlb9 db9 0 1000000000000.0
Chb9 db9 ref 20p IC=-5
Clb9 db9 0 20p IC=0
Rb10 b db10 42197.5970216147
Rhb10 db10 ref 1e12
Rlb10 db10 0 1000000000000.0
Chb10 db10 ref 20p IC=-5
Clb10 db10 0 20p IC=0
Rb11 b db11 42197.5970216147
Rhb11 db11 ref 1e12
Rlb11 db11 0 1000000000000.0
Chb11 db11 ref 20p IC=-5
Clb11 db11 0 20p IC=0
Rb12 b db12 42197.5970216147
Rhb12 db12 ref 1e12
Rlb12 db12 0 1000000000000.0
Chb12 db12 ref 20p IC=-5
Clb12 db12 0 20p IC=0
Rb13 b db13 42197.5970216147
Rhb13 db13 ref 1e12
Rlb13 db13 0 1000000000000.0
Chb13 db13 ref 20p IC=-5
Clb13 db13 0 20p IC=0
Rb14 b db14 42197.5970216147
Rhb14 db14 ref 1e12
Rlb14 db14 0 1000000000000.0
Chb14 db14 ref 20p IC=-5
Clb14 db14 0 20p IC=0
Rb15 b db15 42197.5970216147
Rhb15 db15 ref 1e12
Rlb15 db15 0 1000000000000.0
Chb15 db15 ref 20p IC=-5
Clb15 db15 0 20p IC=0
Rtb b 0 21605169.6750667
Rp a p 160
Lp p b 150.0 IC=-5e-05
Ls s 0 0.126023944549464 IC=0
K1 Lp Ls 0.999973332977768
Rs s out .2
Rload out 0 1000000000.0
Rcore p b 100000.0
Cpri p b 100p IC=0
.save all
.tran 1.0u 0.02 0 1.0u UIC
.end
